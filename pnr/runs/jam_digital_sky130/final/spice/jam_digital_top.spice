* NGSPICE file created from jam_digital_top.ext - technology: sky130A

* Black-box entry subcircuit for sky130_fd_sc_hd__fill_2 abstract view
.subckt sky130_fd_sc_hd__fill_2 VGND VNB VPB VPWR
.ends

* Black-box entry subcircuit for sky130_fd_sc_hd__decap_3 abstract view
.subckt sky130_fd_sc_hd__decap_3 VGND VNB VPB VPWR
.ends

* Black-box entry subcircuit for sky130_fd_sc_hd__o21ba_2 abstract view
.subckt sky130_fd_sc_hd__o21ba_2 A1 A2 B1_N VGND VNB VPB VPWR X
.ends

* Black-box entry subcircuit for sky130_fd_sc_hd__a21oi_2 abstract view
.subckt sky130_fd_sc_hd__a21oi_2 A1 A2 B1 VGND VNB VPB VPWR Y
.ends

* Black-box entry subcircuit for sky130_fd_sc_hd__a31oi_2 abstract view
.subckt sky130_fd_sc_hd__a31oi_2 A1 A2 A3 B1 VGND VNB VPB VPWR Y
.ends

* Black-box entry subcircuit for sky130_fd_sc_hd__o211a_2 abstract view
.subckt sky130_fd_sc_hd__o211a_2 A1 A2 B1 C1 VGND VNB VPB VPWR X
.ends

* Black-box entry subcircuit for sky130_fd_sc_hd__or3_2 abstract view
.subckt sky130_fd_sc_hd__or3_2 A B C VGND VNB VPB VPWR X
.ends

* Black-box entry subcircuit for sky130_fd_sc_hd__tapvpwrvgnd_1 abstract view
.subckt sky130_fd_sc_hd__tapvpwrvgnd_1 VGND VPWR
.ends

* Black-box entry subcircuit for sky130_fd_sc_hd__clkbuf_8 abstract view
.subckt sky130_fd_sc_hd__clkbuf_8 A VGND VNB VPB VPWR X
.ends

* Black-box entry subcircuit for sky130_fd_sc_hd__and3b_2 abstract view
.subckt sky130_fd_sc_hd__and3b_2 A_N B C VGND VNB VPB VPWR X
.ends

* Black-box entry subcircuit for sky130_fd_sc_hd__dfrtp_2 abstract view
.subckt sky130_fd_sc_hd__dfrtp_2 CLK D RESET_B VGND VNB VPB VPWR Q
.ends

* Black-box entry subcircuit for sky130_fd_sc_hd__clkbuf_4 abstract view
.subckt sky130_fd_sc_hd__clkbuf_4 A VGND VNB VPB VPWR X
.ends

* Black-box entry subcircuit for sky130_fd_sc_hd__fill_1 abstract view
.subckt sky130_fd_sc_hd__fill_1 VGND VNB VPB VPWR
.ends

* Black-box entry subcircuit for sky130_fd_sc_hd__o21ai_2 abstract view
.subckt sky130_fd_sc_hd__o21ai_2 A1 A2 B1 VGND VNB VPB VPWR Y
.ends

* Black-box entry subcircuit for sky130_fd_sc_hd__clkdlybuf4s25_1 abstract view
.subckt sky130_fd_sc_hd__clkdlybuf4s25_1 A VGND VNB VPB VPWR X
.ends

* Black-box entry subcircuit for sky130_fd_sc_hd__a31o_2 abstract view
.subckt sky130_fd_sc_hd__a31o_2 A1 A2 A3 B1 VGND VNB VPB VPWR X
.ends

* Black-box entry subcircuit for sky130_fd_sc_hd__a22o_2 abstract view
.subckt sky130_fd_sc_hd__a22o_2 A1 A2 B1 B2 VGND VNB VPB VPWR X
.ends

* Black-box entry subcircuit for sky130_fd_sc_hd__a41o_2 abstract view
.subckt sky130_fd_sc_hd__a41o_2 A1 A2 A3 A4 B1 VGND VNB VPB VPWR X
.ends

* Black-box entry subcircuit for sky130_fd_sc_hd__or3b_2 abstract view
.subckt sky130_fd_sc_hd__or3b_2 A B C_N VGND VNB VPB VPWR X
.ends

* Black-box entry subcircuit for sky130_fd_sc_hd__nand2_2 abstract view
.subckt sky130_fd_sc_hd__nand2_2 A B VGND VNB VPB VPWR Y
.ends

* Black-box entry subcircuit for sky130_fd_sc_hd__nor3_2 abstract view
.subckt sky130_fd_sc_hd__nor3_2 A B C VGND VNB VPB VPWR Y
.ends

* Black-box entry subcircuit for sky130_fd_sc_hd__nor2_2 abstract view
.subckt sky130_fd_sc_hd__nor2_2 A B VGND VNB VPB VPWR Y
.ends

* Black-box entry subcircuit for sky130_fd_sc_hd__or4b_2 abstract view
.subckt sky130_fd_sc_hd__or4b_2 A B C D_N VGND VNB VPB VPWR X
.ends

* Black-box entry subcircuit for sky130_fd_sc_hd__dfstp_2 abstract view
.subckt sky130_fd_sc_hd__dfstp_2 CLK D SET_B VGND VNB VPB VPWR Q
.ends

* Black-box entry subcircuit for sky130_fd_sc_hd__o311a_2 abstract view
.subckt sky130_fd_sc_hd__o311a_2 A1 A2 A3 B1 C1 VGND VNB VPB VPWR X
.ends

* Black-box entry subcircuit for sky130_fd_sc_hd__dlygate4sd3_1 abstract view
.subckt sky130_fd_sc_hd__dlygate4sd3_1 A VGND VNB VPB VPWR X
.ends

* Black-box entry subcircuit for sky130_fd_sc_hd__and2_2 abstract view
.subckt sky130_fd_sc_hd__and2_2 A B VGND VNB VPB VPWR X
.ends

* Black-box entry subcircuit for sky130_fd_sc_hd__inv_2 abstract view
.subckt sky130_fd_sc_hd__inv_2 A VGND VNB VPB VPWR Y
.ends

* Black-box entry subcircuit for sky130_fd_sc_hd__and3_2 abstract view
.subckt sky130_fd_sc_hd__and3_2 A B C VGND VNB VPB VPWR X
.ends

* Black-box entry subcircuit for sky130_fd_sc_hd__o21bai_2 abstract view
.subckt sky130_fd_sc_hd__o21bai_2 A1 A2 B1_N VGND VNB VPB VPWR Y
.ends

* Black-box entry subcircuit for sky130_fd_sc_hd__buf_2 abstract view
.subckt sky130_fd_sc_hd__buf_2 A VGND VNB VPB VPWR X
.ends

* Black-box entry subcircuit for sky130_fd_sc_hd__conb_1 abstract view
.subckt sky130_fd_sc_hd__conb_1 VGND VNB VPB VPWR HI LO
.ends

* Black-box entry subcircuit for sky130_fd_sc_hd__buf_4 abstract view
.subckt sky130_fd_sc_hd__buf_4 A VGND VNB VPB VPWR X
.ends

* Black-box entry subcircuit for sky130_fd_sc_hd__mux2_1 abstract view
.subckt sky130_fd_sc_hd__mux2_1 A0 A1 S VGND VNB VPB VPWR X
.ends

* Black-box entry subcircuit for sky130_fd_sc_hd__a21boi_2 abstract view
.subckt sky130_fd_sc_hd__a21boi_2 A1 A2 B1_N VGND VNB VPB VPWR Y
.ends

* Black-box entry subcircuit for sky130_fd_sc_hd__a21o_2 abstract view
.subckt sky130_fd_sc_hd__a21o_2 A1 A2 B1 VGND VNB VPB VPWR X
.ends

* Black-box entry subcircuit for sky130_fd_sc_hd__o22a_2 abstract view
.subckt sky130_fd_sc_hd__o22a_2 A1 A2 B1 B2 VGND VNB VPB VPWR X
.ends

* Black-box entry subcircuit for sky130_fd_sc_hd__nand3_2 abstract view
.subckt sky130_fd_sc_hd__nand3_2 A B C VGND VNB VPB VPWR Y
.ends

* Black-box entry subcircuit for sky130_fd_sc_hd__or2_2 abstract view
.subckt sky130_fd_sc_hd__or2_2 A B VGND VNB VPB VPWR X
.ends

* Black-box entry subcircuit for sky130_fd_sc_hd__clkbuf_16 abstract view
.subckt sky130_fd_sc_hd__clkbuf_16 A VGND VNB VPB VPWR X
.ends

* Black-box entry subcircuit for sky130_fd_sc_hd__a21bo_2 abstract view
.subckt sky130_fd_sc_hd__a21bo_2 A1 A2 B1_N VGND VNB VPB VPWR X
.ends

* Black-box entry subcircuit for sky130_fd_sc_hd__o21a_2 abstract view
.subckt sky130_fd_sc_hd__o21a_2 A1 A2 B1 VGND VNB VPB VPWR X
.ends

* Black-box entry subcircuit for sky130_fd_sc_hd__clkbuf_2 abstract view
.subckt sky130_fd_sc_hd__clkbuf_2 A VGND VNB VPB VPWR X
.ends

* Black-box entry subcircuit for sky130_fd_sc_hd__a2111oi_2 abstract view
.subckt sky130_fd_sc_hd__a2111oi_2 A1 A2 B1 C1 D1 VGND VNB VPB VPWR Y
.ends

* Black-box entry subcircuit for sky130_fd_sc_hd__and4_2 abstract view
.subckt sky130_fd_sc_hd__and4_2 A B C D VGND VNB VPB VPWR X
.ends

* Black-box entry subcircuit for sky130_fd_sc_hd__a311o_2 abstract view
.subckt sky130_fd_sc_hd__a311o_2 A1 A2 A3 B1 C1 VGND VNB VPB VPWR X
.ends

* Black-box entry subcircuit for sky130_fd_sc_hd__xnor2_2 abstract view
.subckt sky130_fd_sc_hd__xnor2_2 A B VGND VNB VPB VPWR Y
.ends

* Black-box entry subcircuit for sky130_fd_sc_hd__a211o_2 abstract view
.subckt sky130_fd_sc_hd__a211o_2 A1 A2 B1 C1 VGND VNB VPB VPWR X
.ends

* Black-box entry subcircuit for sky130_fd_sc_hd__a311oi_2 abstract view
.subckt sky130_fd_sc_hd__a311oi_2 A1 A2 A3 B1 C1 VGND VNB VPB VPWR Y
.ends

* Black-box entry subcircuit for sky130_fd_sc_hd__o221a_2 abstract view
.subckt sky130_fd_sc_hd__o221a_2 A1 A2 B1 B2 C1 VGND VNB VPB VPWR X
.ends

* Black-box entry subcircuit for sky130_fd_sc_hd__and4bb_2 abstract view
.subckt sky130_fd_sc_hd__and4bb_2 A_N B_N C D VGND VNB VPB VPWR X
.ends

* Black-box entry subcircuit for sky130_fd_sc_hd__xor2_2 abstract view
.subckt sky130_fd_sc_hd__xor2_2 A B VGND VNB VPB VPWR X
.ends

* Black-box entry subcircuit for sky130_fd_sc_hd__nor3b_2 abstract view
.subckt sky130_fd_sc_hd__nor3b_2 A B C_N VGND VNB VPB VPWR Y
.ends

* Black-box entry subcircuit for sky130_fd_sc_hd__a2bb2o_2 abstract view
.subckt sky130_fd_sc_hd__a2bb2o_2 A1_N A2_N B1 B2 VGND VNB VPB VPWR X
.ends

* Black-box entry subcircuit for sky130_fd_sc_hd__a221o_2 abstract view
.subckt sky130_fd_sc_hd__a221o_2 A1 A2 B1 B2 C1 VGND VNB VPB VPWR X
.ends

* Black-box entry subcircuit for sky130_fd_sc_hd__a211oi_2 abstract view
.subckt sky130_fd_sc_hd__a211oi_2 A1 A2 B1 C1 VGND VNB VPB VPWR Y
.ends

* Black-box entry subcircuit for sky130_fd_sc_hd__and2b_2 abstract view
.subckt sky130_fd_sc_hd__and2b_2 A_N B VGND VNB VPB VPWR X
.ends

* Black-box entry subcircuit for sky130_fd_sc_hd__a2111o_2 abstract view
.subckt sky130_fd_sc_hd__a2111o_2 A1 A2 B1 C1 D1 VGND VNB VPB VPWR X
.ends

* Black-box entry subcircuit for sky130_fd_sc_hd__or4_2 abstract view
.subckt sky130_fd_sc_hd__or4_2 A B C D VGND VNB VPB VPWR X
.ends

* Black-box entry subcircuit for sky130_fd_sc_hd__nand4_2 abstract view
.subckt sky130_fd_sc_hd__nand4_2 A B C D VGND VNB VPB VPWR Y
.ends

* Black-box entry subcircuit for sky130_fd_sc_hd__and4b_2 abstract view
.subckt sky130_fd_sc_hd__and4b_2 A_N B C D VGND VNB VPB VPWR X
.ends

* Black-box entry subcircuit for sky130_fd_sc_hd__o31ai_2 abstract view
.subckt sky130_fd_sc_hd__o31ai_2 A1 A2 A3 B1 VGND VNB VPB VPWR Y
.ends

.subckt jam_digital_top VGND VPWR am_pm_o clk digit_sel_o[0] digit_sel_o[1] digit_sel_o[2]
+ digit_sel_o[3] digit_sel_o[4] digit_sel_o[5] en_i fast_mode_i hour_ones_o[0] hour_ones_o[1]
+ hour_ones_o[2] hour_ones_o[3] hour_tens_o[0] hour_tens_o[1] hour_tens_o[2] hour_tens_o[3]
+ inc_hour_i inc_min_i inc_sec_i load_en_i load_hour_ones_i[0] load_hour_ones_i[1]
+ load_hour_ones_i[2] load_hour_ones_i[3] load_hour_tens_i[0] load_hour_tens_i[1]
+ load_hour_tens_i[2] load_hour_tens_i[3] load_min_ones_i[0] load_min_ones_i[1] load_min_ones_i[2]
+ load_min_ones_i[3] load_min_tens_i[0] load_min_tens_i[1] load_min_tens_i[2] load_min_tens_i[3]
+ load_sec_ones_i[0] load_sec_ones_i[1] load_sec_ones_i[2] load_sec_ones_i[3] load_sec_tens_i[0]
+ load_sec_tens_i[1] load_sec_tens_i[2] load_sec_tens_i[3] min_ones_o[0] min_ones_o[1]
+ min_ones_o[2] min_ones_o[3] min_tens_o[0] min_tens_o[1] min_tens_o[2] min_tens_o[3]
+ rollover_pulse_o rst_n sec_ones_o[0] sec_ones_o[1] sec_ones_o[2] sec_ones_o[3] sec_tens_o[0]
+ sec_tens_o[1] sec_tens_o[2] sec_tens_o[3] seg_o[0] seg_o[1] seg_o[2] seg_o[3] seg_o[4]
+ seg_o[5] seg_o[6] tick_1hz_o
XFILLER_39_222 VGND VGND VPWR VPWR sky130_fd_sc_hd__fill_2
XFILLER_22_144 VGND VGND VPWR VPWR sky130_fd_sc_hd__decap_3
XFILLER_22_177 VGND VGND VPWR VPWR sky130_fd_sc_hd__decap_3
XFILLER_13_122 VGND VGND VPWR VPWR sky130_fd_sc_hd__fill_2
X_501_ _502_/A1 _498_/X _500_/X VGND VGND VPWR VPWR _656_/D sky130_fd_sc_hd__o21ba_2
X_432_ _430_/X _431_/X _703_/D VGND VGND VPWR VPWR _702_/D sky130_fd_sc_hd__a21oi_2
X_363_ _364_/B _361_/Y _362_/X _364_/A VGND VGND VPWR VPWR _626_/D sky130_fd_sc_hd__a31oi_2
XFILLER_9_137 VGND VGND VPWR VPWR sky130_fd_sc_hd__decap_3
XFILLER_3_45 VGND VGND VPWR VPWR sky130_fd_sc_hd__decap_3
XFILLER_3_12 VGND VGND VPWR VPWR sky130_fd_sc_hd__decap_3
XFILLER_3_78 VGND VGND VPWR VPWR sky130_fd_sc_hd__decap_3
XFILLER_27_225 VGND VGND VPWR VPWR sky130_fd_sc_hd__decap_3
XFILLER_10_125 VGND VGND VPWR VPWR sky130_fd_sc_hd__decap_3
XFILLER_12_43 VGND VGND VPWR VPWR sky130_fd_sc_hd__decap_3
XFILLER_18_203 VGND VGND VPWR VPWR sky130_fd_sc_hd__fill_2
X_415_ _415_/A1 _413_/A _414_/Y _407_/A VGND VGND VPWR VPWR _696_/D sky130_fd_sc_hd__o211a_2
X_346_ _346_/A _346_/B _346_/C VGND VGND VPWR VPWR _346_/X sky130_fd_sc_hd__or3_2
XTAP_TAPCELL_ROW_11_131 VGND VPWR sky130_fd_sc_hd__tapvpwrvgnd_1
XTAP_TAPCELL_ROW_34_223 VGND VPWR sky130_fd_sc_hd__tapvpwrvgnd_1
XPHY_EDGE_ROW_20_Left_61 VGND VGND VPWR VPWR sky130_fd_sc_hd__decap_3
Xclkbuf_4_12_0_clk clkbuf_0_clk/X VGND VGND VPWR VPWR _703_/CLK sky130_fd_sc_hd__clkbuf_8
XFILLER_15_228 VGND VGND VPWR VPWR sky130_fd_sc_hd__decap_3
XTAP_TAPCELL_ROW_40_248 VGND VPWR sky130_fd_sc_hd__tapvpwrvgnd_1
XFILLER_2_176 VGND VGND VPWR VPWR sky130_fd_sc_hd__fill_2
XFILLER_0_24 VGND VGND VPWR VPWR sky130_fd_sc_hd__decap_3
XFILLER_0_35 VGND VGND VPWR VPWR sky130_fd_sc_hd__decap_3
XFILLER_0_57 VGND VGND VPWR VPWR sky130_fd_sc_hd__decap_3
X_329_ _686_/Q _685_/Q _684_/Q VGND VGND VPWR VPWR _633_/D sky130_fd_sc_hd__and3b_2
XFILLER_9_44 VGND VGND VPWR VPWR sky130_fd_sc_hd__decap_3
X_680_ _709_/CLK _680_/D load_slew89/X VGND VGND VPWR VPWR _680_/Q sky130_fd_sc_hd__dfrtp_2
XFILLER_34_85 VGND VGND VPWR VPWR sky130_fd_sc_hd__decap_3
XFILLER_34_52 VGND VGND VPWR VPWR sky130_fd_sc_hd__decap_3
XFILLER_15_6 VGND VGND VPWR VPWR sky130_fd_sc_hd__decap_3
Xload_slew85 fanout84/X VGND VGND VPWR VPWR load_slew85/X sky130_fd_sc_hd__clkbuf_4
XFILLER_29_106 VGND VGND VPWR VPWR sky130_fd_sc_hd__decap_3
XFILLER_29_128 VGND VGND VPWR VPWR sky130_fd_sc_hd__decap_3
XFILLER_20_21 VGND VGND VPWR VPWR sky130_fd_sc_hd__decap_3
XFILLER_20_54 VGND VGND VPWR VPWR sky130_fd_sc_hd__decap_3
XFILLER_29_63 VGND VGND VPWR VPWR sky130_fd_sc_hd__fill_1
XFILLER_29_85 VGND VGND VPWR VPWR sky130_fd_sc_hd__decap_3
XFILLER_28_150 VGND VGND VPWR VPWR sky130_fd_sc_hd__decap_3
XFILLER_28_172 VGND VGND VPWR VPWR sky130_fd_sc_hd__decap_3
X_594_ _604_/A _593_/Y _588_/X VGND VGND VPWR VPWR _594_/Y sky130_fd_sc_hd__o21ai_2
X_663_ _667_/CLK _663_/D fanout91/X VGND VGND VPWR VPWR _663_/Q sky130_fd_sc_hd__dfrtp_2
XFILLER_6_12 VGND VGND VPWR VPWR sky130_fd_sc_hd__decap_3
XFILLER_6_56 VGND VGND VPWR VPWR sky130_fd_sc_hd__decap_3
XFILLER_13_3 VGND VGND VPWR VPWR sky130_fd_sc_hd__decap_3
XFILLER_19_172 VGND VGND VPWR VPWR sky130_fd_sc_hd__decap_3
XFILLER_34_186 VGND VGND VPWR VPWR sky130_fd_sc_hd__decap_3
XFILLER_34_120 VGND VGND VPWR VPWR sky130_fd_sc_hd__decap_3
XFILLER_15_21 VGND VGND VPWR VPWR sky130_fd_sc_hd__decap_3
XFILLER_25_131 VGND VGND VPWR VPWR sky130_fd_sc_hd__decap_3
XFILLER_25_153 VGND VGND VPWR VPWR sky130_fd_sc_hd__fill_2
XFILLER_15_87 VGND VGND VPWR VPWR sky130_fd_sc_hd__decap_3
XFILLER_31_42 VGND VGND VPWR VPWR sky130_fd_sc_hd__decap_3
Xoutput64 _626_/Q VGND VGND VPWR VPWR seg_o[3] sky130_fd_sc_hd__clkdlybuf4s25_1
Xoutput53 _680_/Q VGND VGND VPWR VPWR sec_ones_o[0] sky130_fd_sc_hd__clkdlybuf4s25_1
Xoutput42 _667_/Q VGND VGND VPWR VPWR hour_ones_o[3] sky130_fd_sc_hd__clkdlybuf4s25_1
XFILLER_31_97 VGND VGND VPWR VPWR sky130_fd_sc_hd__decap_3
XFILLER_16_131 VGND VGND VPWR VPWR sky130_fd_sc_hd__decap_3
XFILLER_16_197 VGND VGND VPWR VPWR sky130_fd_sc_hd__decap_3
X_577_ _552_/A _575_/X _576_/Y _574_/X VGND VGND VPWR VPWR _577_/X sky130_fd_sc_hd__a31o_2
X_646_ _684_/CLK _646_/D load_slew83/X VGND VGND VPWR VPWR _646_/Q sky130_fd_sc_hd__dfrtp_2
XTAP_TAPCELL_ROW_26_192 VGND VPWR sky130_fd_sc_hd__tapvpwrvgnd_1
XTAP_TAPCELL_ROW_18_159 VGND VPWR sky130_fd_sc_hd__tapvpwrvgnd_1
XFILLER_31_178 VGND VGND VPWR VPWR sky130_fd_sc_hd__decap_3
XFILLER_39_234 VGND VGND VPWR VPWR sky130_fd_sc_hd__decap_3
XFILLER_39_201 VGND VGND VPWR VPWR sky130_fd_sc_hd__decap_3
XFILLER_22_134 VGND VGND VPWR VPWR sky130_fd_sc_hd__decap_3
XFILLER_22_156 VGND VGND VPWR VPWR sky130_fd_sc_hd__decap_3
X_500_ _507_/B _515_/B _498_/X _656_/Q VGND VGND VPWR VPWR _500_/X sky130_fd_sc_hd__a22o_2
XFILLER_13_101 VGND VGND VPWR VPWR sky130_fd_sc_hd__decap_3
XFILLER_13_156 VGND VGND VPWR VPWR sky130_fd_sc_hd__decap_3
XFILLER_26_53 VGND VGND VPWR VPWR sky130_fd_sc_hd__decap_3
X_431_ _700_/Q _699_/Q _701_/Q _421_/B _310_/Y VGND VGND VPWR VPWR _431_/X sky130_fd_sc_hd__a41o_2
X_362_ _362_/A _362_/B _351_/X VGND VGND VPWR VPWR _362_/X sky130_fd_sc_hd__or3b_2
XFILLER_13_178 VGND VGND VPWR VPWR sky130_fd_sc_hd__decap_3
XFILLER_9_149 VGND VGND VPWR VPWR sky130_fd_sc_hd__decap_3
XFILLER_3_24 VGND VGND VPWR VPWR sky130_fd_sc_hd__decap_3
X_629_ _665_/CLK _629_/D _628_/SET_B VGND VGND VPWR VPWR _629_/Q sky130_fd_sc_hd__dfrtp_2
XFILLER_27_215 VGND VGND VPWR VPWR sky130_fd_sc_hd__decap_3
XFILLER_10_115 VGND VGND VPWR VPWR sky130_fd_sc_hd__fill_2
XFILLER_10_137 VGND VGND VPWR VPWR sky130_fd_sc_hd__decap_3
XFILLER_18_226 VGND VGND VPWR VPWR sky130_fd_sc_hd__decap_3
XFILLER_37_52 VGND VGND VPWR VPWR sky130_fd_sc_hd__decap_3
X_414_ _419_/C _419_/D VGND VGND VPWR VPWR _414_/Y sky130_fd_sc_hd__nand2_2
X_345_ _671_/Q _633_/D _333_/Y _675_/Q VGND VGND VPWR VPWR _346_/C sky130_fd_sc_hd__a22o_2
XTAP_TAPCELL_ROW_11_132 VGND VPWR sky130_fd_sc_hd__tapvpwrvgnd_1
XFILLER_5_196 VGND VGND VPWR VPWR sky130_fd_sc_hd__decap_3
XFILLER_24_207 VGND VGND VPWR VPWR sky130_fd_sc_hd__decap_3
XTAP_TAPCELL_ROW_34_224 VGND VPWR sky130_fd_sc_hd__tapvpwrvgnd_1
XPHY_EDGE_ROW_12_Right_12 VGND VGND VPWR VPWR sky130_fd_sc_hd__decap_3
XPHY_EDGE_ROW_21_Right_21 VGND VGND VPWR VPWR sky130_fd_sc_hd__decap_3
XFILLER_23_54 VGND VGND VPWR VPWR sky130_fd_sc_hd__fill_2
XTAP_TAPCELL_ROW_40_249 VGND VPWR sky130_fd_sc_hd__tapvpwrvgnd_1
XFILLER_2_122 VGND VGND VPWR VPWR sky130_fd_sc_hd__decap_3
XPHY_EDGE_ROW_30_Right_30 VGND VGND VPWR VPWR sky130_fd_sc_hd__decap_3
XFILLER_2_144 VGND VGND VPWR VPWR sky130_fd_sc_hd__decap_3
XFILLER_0_47 VGND VGND VPWR VPWR sky130_fd_sc_hd__decap_3
XFILLER_0_69 VGND VGND VPWR VPWR sky130_fd_sc_hd__decap_3
XFILLER_9_12 VGND VGND VPWR VPWR sky130_fd_sc_hd__decap_3
X_328_ _686_/Q _685_/Q _684_/Q VGND VGND VPWR VPWR _328_/Y sky130_fd_sc_hd__nor3_2
XFILLER_9_89 VGND VGND VPWR VPWR sky130_fd_sc_hd__decap_3
XFILLER_7_225 VGND VGND VPWR VPWR sky130_fd_sc_hd__decap_3
XFILLER_34_97 VGND VGND VPWR VPWR sky130_fd_sc_hd__decap_3
Xclkbuf_4_11_0_clk clkbuf_0_clk/X VGND VGND VPWR VPWR _712_/CLK sky130_fd_sc_hd__clkbuf_8
Xload_slew97 fanout96/X VGND VGND VPWR VPWR _630_/SET_B sky130_fd_sc_hd__clkbuf_4
Xload_slew75 _534_/B1 VGND VGND VPWR VPWR _533_/A sky130_fd_sc_hd__clkbuf_4
XFILLER_20_66 VGND VGND VPWR VPWR sky130_fd_sc_hd__decap_3
XFILLER_20_99 VGND VGND VPWR VPWR sky130_fd_sc_hd__decap_3
XFILLER_29_97 VGND VGND VPWR VPWR sky130_fd_sc_hd__decap_3
X_662_ _703_/CLK _662_/D load_slew85/X VGND VGND VPWR VPWR _662_/Q sky130_fd_sc_hd__dfrtp_2
XFILLER_28_184 VGND VGND VPWR VPWR sky130_fd_sc_hd__fill_1
X_593_ _593_/A _593_/B VGND VGND VPWR VPWR _593_/Y sky130_fd_sc_hd__nor2_2
XFILLER_6_35 VGND VGND VPWR VPWR sky130_fd_sc_hd__decap_3
XFILLER_6_24 VGND VGND VPWR VPWR sky130_fd_sc_hd__decap_3
XFILLER_6_68 VGND VGND VPWR VPWR sky130_fd_sc_hd__fill_2
XFILLER_19_162 VGND VGND VPWR VPWR sky130_fd_sc_hd__decap_3
XFILLER_19_184 VGND VGND VPWR VPWR sky130_fd_sc_hd__decap_3
XFILLER_34_132 VGND VGND VPWR VPWR sky130_fd_sc_hd__decap_3
XPHY_EDGE_ROW_6_Right_6 VGND VGND VPWR VPWR sky130_fd_sc_hd__decap_3
XFILLER_15_55 VGND VGND VPWR VPWR sky130_fd_sc_hd__fill_1
XFILLER_15_66 VGND VGND VPWR VPWR sky130_fd_sc_hd__decap_3
XFILLER_25_165 VGND VGND VPWR VPWR sky130_fd_sc_hd__decap_3
XFILLER_25_187 VGND VGND VPWR VPWR sky130_fd_sc_hd__fill_1
XFILLER_40_113 VGND VGND VPWR VPWR sky130_fd_sc_hd__fill_1
XFILLER_15_99 VGND VGND VPWR VPWR sky130_fd_sc_hd__decap_3
XFILLER_31_54 VGND VGND VPWR VPWR sky130_fd_sc_hd__fill_2
XFILLER_31_21 VGND VGND VPWR VPWR sky130_fd_sc_hd__decap_3
XFILLER_0_231 VGND VGND VPWR VPWR sky130_fd_sc_hd__decap_3
Xoutput65 _627_/Q VGND VGND VPWR VPWR seg_o[4] sky130_fd_sc_hd__clkdlybuf4s25_1
Xoutput54 _681_/Q VGND VGND VPWR VPWR sec_ones_o[1] sky130_fd_sc_hd__clkdlybuf4s25_1
Xoutput43 _636_/Q VGND VGND VPWR VPWR hour_tens_o[0] sky130_fd_sc_hd__clkdlybuf4s25_1
Xoutput32 _663_/Q VGND VGND VPWR VPWR am_pm_o sky130_fd_sc_hd__clkdlybuf4s25_1
X_645_ _708_/CLK _645_/D load_slew85/X VGND VGND VPWR VPWR _645_/Q sky130_fd_sc_hd__dfrtp_2
XFILLER_16_165 VGND VGND VPWR VPWR sky130_fd_sc_hd__decap_3
X_576_ _576_/A _576_/B VGND VGND VPWR VPWR _576_/Y sky130_fd_sc_hd__nand2_2
XTAP_TAPCELL_ROW_26_193 VGND VPWR sky130_fd_sc_hd__tapvpwrvgnd_1
XFILLER_31_113 VGND VGND VPWR VPWR sky130_fd_sc_hd__decap_3
XFILLER_39_213 VGND VGND VPWR VPWR sky130_fd_sc_hd__decap_3
XFILLER_7_9 VGND VGND VPWR VPWR sky130_fd_sc_hd__decap_3
XFILLER_13_113 VGND VGND VPWR VPWR sky130_fd_sc_hd__decap_3
XFILLER_13_135 VGND VGND VPWR VPWR sky130_fd_sc_hd__decap_3
XFILLER_26_65 VGND VGND VPWR VPWR sky130_fd_sc_hd__decap_3
X_430_ _430_/A _430_/B _430_/C _421_/B VGND VGND VPWR VPWR _430_/X sky130_fd_sc_hd__or4b_2
X_361_ _362_/A _362_/B _346_/X VGND VGND VPWR VPWR _361_/Y sky130_fd_sc_hd__a21oi_2
XFILLER_3_36 VGND VGND VPWR VPWR sky130_fd_sc_hd__decap_3
X_628_ _670_/CLK _628_/D _628_/SET_B VGND VGND VPWR VPWR _628_/Q sky130_fd_sc_hd__dfstp_2
XFILLER_12_190 VGND VGND VPWR VPWR sky130_fd_sc_hd__decap_3
X_559_ _574_/C _372_/X _561_/B _558_/Y _556_/A VGND VGND VPWR VPWR _559_/X sky130_fd_sc_hd__o311a_2
XFILLER_8_150 VGND VGND VPWR VPWR sky130_fd_sc_hd__decap_3
XTAP_TAPCELL_ROW_20_166 VGND VPWR sky130_fd_sc_hd__tapvpwrvgnd_1
Xhold150 _686_/Q VGND VGND VPWR VPWR _333_/A sky130_fd_sc_hd__dlygate4sd3_1
XFILLER_5_6 VGND VGND VPWR VPWR sky130_fd_sc_hd__decap_3
X_413_ _413_/A _413_/B VGND VGND VPWR VPWR _413_/Y sky130_fd_sc_hd__nor2_2
XTAP_TAPCELL_ROW_28_200 VGND VPWR sky130_fd_sc_hd__tapvpwrvgnd_1
XFILLER_37_97 VGND VGND VPWR VPWR sky130_fd_sc_hd__decap_3
XFILLER_37_64 VGND VGND VPWR VPWR sky130_fd_sc_hd__fill_1
XFILLER_33_208 VGND VGND VPWR VPWR sky130_fd_sc_hd__fill_1
X_344_ _667_/Q _634_/D VGND VGND VPWR VPWR _346_/B sky130_fd_sc_hd__and2_2
XTAP_TAPCELL_ROW_11_133 VGND VPWR sky130_fd_sc_hd__tapvpwrvgnd_1
XFILLER_5_131 VGND VGND VPWR VPWR sky130_fd_sc_hd__decap_3
XTAP_TAPCELL_ROW_34_225 VGND VPWR sky130_fd_sc_hd__tapvpwrvgnd_1
XFILLER_2_134 VGND VGND VPWR VPWR sky130_fd_sc_hd__decap_3
XFILLER_3_3 VGND VGND VPWR VPWR sky130_fd_sc_hd__decap_3
XFILLER_0_15 VGND VGND VPWR VPWR sky130_fd_sc_hd__decap_3
X_327_ _407_/A VGND VGND VPWR VPWR _703_/D sky130_fd_sc_hd__inv_2
XFILLER_9_57 VGND VGND VPWR VPWR sky130_fd_sc_hd__fill_2
XFILLER_36_3 VGND VGND VPWR VPWR sky130_fd_sc_hd__decap_3
XPHY_EDGE_ROW_8_Left_49 VGND VGND VPWR VPWR sky130_fd_sc_hd__decap_3
XFILLER_34_21 VGND VGND VPWR VPWR sky130_fd_sc_hd__decap_3
Xload_slew87 fanout86/X VGND VGND VPWR VPWR load_slew87/X sky130_fd_sc_hd__clkbuf_4
XFILLER_29_119 VGND VGND VPWR VPWR sky130_fd_sc_hd__decap_3
XFILLER_37_196 VGND VGND VPWR VPWR sky130_fd_sc_hd__fill_2
XFILLER_20_12 VGND VGND VPWR VPWR sky130_fd_sc_hd__decap_3
XFILLER_20_45 VGND VGND VPWR VPWR sky130_fd_sc_hd__decap_3
XFILLER_4_218 VGND VGND VPWR VPWR sky130_fd_sc_hd__decap_3
XFILLER_28_141 VGND VGND VPWR VPWR sky130_fd_sc_hd__decap_3
XFILLER_28_163 VGND VGND VPWR VPWR sky130_fd_sc_hd__decap_3
XFILLER_29_21 VGND VGND VPWR VPWR sky130_fd_sc_hd__decap_3
XFILLER_29_54 VGND VGND VPWR VPWR sky130_fd_sc_hd__fill_2
XFILLER_29_76 VGND VGND VPWR VPWR sky130_fd_sc_hd__decap_3
X_592_ _677_/Q _676_/Q _678_/Q VGND VGND VPWR VPWR _593_/B sky130_fd_sc_hd__and3_2
X_661_ _708_/CLK _661_/D fanout88/X VGND VGND VPWR VPWR _661_/Q sky130_fd_sc_hd__dfrtp_2
XFILLER_6_47 VGND VGND VPWR VPWR sky130_fd_sc_hd__decap_3
XFILLER_19_196 VGND VGND VPWR VPWR sky130_fd_sc_hd__fill_1
XFILLER_34_144 VGND VGND VPWR VPWR sky130_fd_sc_hd__decap_3
XFILLER_34_111 VGND VGND VPWR VPWR sky130_fd_sc_hd__decap_3
XFILLER_34_100 VGND VGND VPWR VPWR sky130_fd_sc_hd__fill_1
XFILLER_34_177 VGND VGND VPWR VPWR sky130_fd_sc_hd__fill_1
XFILLER_15_12 VGND VGND VPWR VPWR sky130_fd_sc_hd__decap_3
XFILLER_15_45 VGND VGND VPWR VPWR sky130_fd_sc_hd__fill_1
XFILLER_15_78 VGND VGND VPWR VPWR sky130_fd_sc_hd__decap_3
XFILLER_25_100 VGND VGND VPWR VPWR sky130_fd_sc_hd__decap_3
Xclkbuf_4_10_0_clk clkbuf_0_clk/X VGND VGND VPWR VPWR _705_/CLK sky130_fd_sc_hd__clkbuf_8
XFILLER_31_88 VGND VGND VPWR VPWR sky130_fd_sc_hd__decap_3
XFILLER_31_33 VGND VGND VPWR VPWR sky130_fd_sc_hd__decap_3
Xoutput66 _628_/Q VGND VGND VPWR VPWR seg_o[5] sky130_fd_sc_hd__clkdlybuf4s25_1
Xoutput55 _682_/Q VGND VGND VPWR VPWR sec_ones_o[2] sky130_fd_sc_hd__clkdlybuf4s25_1
Xoutput44 _672_/Q VGND VGND VPWR VPWR min_ones_o[0] sky130_fd_sc_hd__clkdlybuf4s25_1
Xoutput33 _630_/Q VGND VGND VPWR VPWR digit_sel_o[0] sky130_fd_sc_hd__clkdlybuf4s25_1
X_575_ _576_/A _576_/B _573_/S VGND VGND VPWR VPWR _575_/X sky130_fd_sc_hd__or3b_2
X_644_ _684_/CLK _644_/D load_slew85/X VGND VGND VPWR VPWR _644_/Q sky130_fd_sc_hd__dfrtp_2
X_713_ _713_/CLK _713_/D load_slew92/X VGND VGND VPWR VPWR _713_/Q sky130_fd_sc_hd__dfrtp_2
XFILLER_31_169 VGND VGND VPWR VPWR sky130_fd_sc_hd__decap_3
XFILLER_39_225 VGND VGND VPWR VPWR sky130_fd_sc_hd__decap_3
XFILLER_22_147 VGND VGND VPWR VPWR sky130_fd_sc_hd__decap_3
XFILLER_7_90 VGND VGND VPWR VPWR sky130_fd_sc_hd__fill_1
XPHY_EDGE_ROW_37_Left_78 VGND VGND VPWR VPWR sky130_fd_sc_hd__decap_3
XFILLER_13_169 VGND VGND VPWR VPWR sky130_fd_sc_hd__decap_3
X_360_ _362_/A _362_/B _351_/X VGND VGND VPWR VPWR _364_/B sky130_fd_sc_hd__o21bai_2
XFILLER_3_48 VGND VGND VPWR VPWR sky130_fd_sc_hd__decap_3
XFILLER_3_15 VGND VGND VPWR VPWR sky130_fd_sc_hd__decap_3
XFILLER_36_206 VGND VGND VPWR VPWR sky130_fd_sc_hd__fill_1
X_558_ _552_/B _552_/C _574_/C VGND VGND VPWR VPWR _558_/Y sky130_fd_sc_hd__o21ai_2
X_627_ _665_/CLK _627_/D _628_/SET_B VGND VGND VPWR VPWR _627_/Q sky130_fd_sc_hd__dfstp_2
X_489_ _522_/A _489_/B _489_/C VGND VGND VPWR VPWR _652_/D sky130_fd_sc_hd__and3_2
XTAP_TAPCELL_ROW_14_142 VGND VPWR sky130_fd_sc_hd__tapvpwrvgnd_1
XFILLER_8_195 VGND VGND VPWR VPWR sky130_fd_sc_hd__fill_1
XFILLER_8_184 VGND VGND VPWR VPWR sky130_fd_sc_hd__fill_1
XFILLER_27_228 VGND VGND VPWR VPWR sky130_fd_sc_hd__fill_1
XTAP_TAPCELL_ROW_37_234 VGND VPWR sky130_fd_sc_hd__tapvpwrvgnd_1
XFILLER_10_106 VGND VGND VPWR VPWR sky130_fd_sc_hd__decap_3
XFILLER_10_128 VGND VGND VPWR VPWR sky130_fd_sc_hd__decap_3
XFILLER_12_24 VGND VGND VPWR VPWR sky130_fd_sc_hd__decap_3
XFILLER_12_46 VGND VGND VPWR VPWR sky130_fd_sc_hd__fill_1
XFILLER_12_68 VGND VGND VPWR VPWR sky130_fd_sc_hd__decap_3
Xhold140 _675_/Q VGND VGND VPWR VPWR _580_/A1 sky130_fd_sc_hd__dlygate4sd3_1
Xhold151 _333_/Y VGND VGND VPWR VPWR _632_/D sky130_fd_sc_hd__dlygate4sd3_1
XTAP_TAPCELL_ROW_20_167 VGND VPWR sky130_fd_sc_hd__tapvpwrvgnd_1
XFILLER_37_21 VGND VGND VPWR VPWR sky130_fd_sc_hd__decap_3
X_412_ _412_/A1 _419_/D _407_/A VGND VGND VPWR VPWR _413_/B sky130_fd_sc_hd__o21ai_2
XTAP_TAPCELL_ROW_28_201 VGND VPWR sky130_fd_sc_hd__tapvpwrvgnd_1
X_343_ _683_/Q _328_/Y _631_/D _679_/Q VGND VGND VPWR VPWR _346_/A sky130_fd_sc_hd__a22o_2
XFILLER_5_187 VGND VGND VPWR VPWR sky130_fd_sc_hd__decap_3
XFILLER_2_113 VGND VGND VPWR VPWR sky130_fd_sc_hd__decap_3
XFILLER_0_27 VGND VGND VPWR VPWR sky130_fd_sc_hd__fill_1
XFILLER_0_38 VGND VGND VPWR VPWR sky130_fd_sc_hd__decap_3
X_326_ _323_/X _325_/X _421_/A VGND VGND VPWR VPWR _407_/A sky130_fd_sc_hd__o21ba_2
XFILLER_9_47 VGND VGND VPWR VPWR sky130_fd_sc_hd__fill_2
Xfanout90 input31/X VGND VGND VPWR VPWR fanout90/X sky130_fd_sc_hd__clkdlybuf4s25_1
XPHY_EDGE_ROW_24_Left_65 VGND VGND VPWR VPWR sky130_fd_sc_hd__decap_3
XFILLER_29_3 VGND VGND VPWR VPWR sky130_fd_sc_hd__decap_3
XFILLER_18_67 VGND VGND VPWR VPWR sky130_fd_sc_hd__fill_2
XFILLER_34_88 VGND VGND VPWR VPWR sky130_fd_sc_hd__decap_3
XFILLER_34_55 VGND VGND VPWR VPWR sky130_fd_sc_hd__decap_3
XFILLER_15_9 VGND VGND VPWR VPWR sky130_fd_sc_hd__decap_3
Xload_slew99 fanout98/X VGND VGND VPWR VPWR load_slew99/X sky130_fd_sc_hd__buf_2
Xload_slew77 _566_/A VGND VGND VPWR VPWR _564_/A sky130_fd_sc_hd__clkbuf_4
X_309_ _701_/Q VGND VGND VPWR VPWR _430_/A sky130_fd_sc_hd__inv_2
XFILLER_29_109 VGND VGND VPWR VPWR sky130_fd_sc_hd__decap_3
XFILLER_20_24 VGND VGND VPWR VPWR sky130_fd_sc_hd__decap_3
XFILLER_20_57 VGND VGND VPWR VPWR sky130_fd_sc_hd__decap_3
XFILLER_28_153 VGND VGND VPWR VPWR sky130_fd_sc_hd__fill_1
XFILLER_28_175 VGND VGND VPWR VPWR sky130_fd_sc_hd__decap_3
XFILLER_28_197 VGND VGND VPWR VPWR sky130_fd_sc_hd__decap_3
XFILLER_29_88 VGND VGND VPWR VPWR sky130_fd_sc_hd__decap_3
X_591_ _585_/A _587_/X _591_/B1 VGND VGND VPWR VPWR _591_/Y sky130_fd_sc_hd__a21oi_2
X_660_ _684_/CLK _660_/D fanout95/X VGND VGND VPWR VPWR _660_/Q sky130_fd_sc_hd__dfrtp_2
XFILLER_6_59 VGND VGND VPWR VPWR sky130_fd_sc_hd__decap_3
XFILLER_6_15 VGND VGND VPWR VPWR sky130_fd_sc_hd__decap_3
XFILLER_13_6 VGND VGND VPWR VPWR sky130_fd_sc_hd__decap_3
XFILLER_19_153 VGND VGND VPWR VPWR sky130_fd_sc_hd__decap_3
XFILLER_19_175 VGND VGND VPWR VPWR sky130_fd_sc_hd__decap_3
XFILLER_34_189 VGND VGND VPWR VPWR sky130_fd_sc_hd__decap_3
XFILLER_34_123 VGND VGND VPWR VPWR sky130_fd_sc_hd__decap_3
XPHY_EDGE_ROW_11_Left_52 VGND VGND VPWR VPWR sky130_fd_sc_hd__decap_3
XFILLER_15_24 VGND VGND VPWR VPWR sky130_fd_sc_hd__decap_3
XFILLER_15_57 VGND VGND VPWR VPWR sky130_fd_sc_hd__decap_3
XFILLER_25_134 VGND VGND VPWR VPWR sky130_fd_sc_hd__decap_3
Xoutput34 _631_/Q VGND VGND VPWR VPWR digit_sel_o[1] sky130_fd_sc_hd__clkdlybuf4s25_1
XFILLER_31_45 VGND VGND VPWR VPWR sky130_fd_sc_hd__decap_3
XFILLER_31_12 VGND VGND VPWR VPWR sky130_fd_sc_hd__decap_3
XFILLER_0_222 VGND VGND VPWR VPWR sky130_fd_sc_hd__fill_2
X_712_ _712_/CLK _712_/D fanout90/X VGND VGND VPWR VPWR _712_/Q sky130_fd_sc_hd__dfrtp_2
Xoutput67 _629_/Q VGND VGND VPWR VPWR seg_o[6] sky130_fd_sc_hd__clkdlybuf4s25_1
Xoutput56 _683_/Q VGND VGND VPWR VPWR sec_ones_o[3] sky130_fd_sc_hd__clkdlybuf4s25_1
Xoutput45 _673_/Q VGND VGND VPWR VPWR min_ones_o[1] sky130_fd_sc_hd__clkdlybuf4s25_1
XFILLER_16_134 VGND VGND VPWR VPWR sky130_fd_sc_hd__decap_3
XFILLER_16_156 VGND VGND VPWR VPWR sky130_fd_sc_hd__fill_1
X_574_ _564_/B _574_/B _574_/C VGND VGND VPWR VPWR _574_/X sky130_fd_sc_hd__and3b_2
X_643_ _684_/CLK _643_/D load_slew83/X VGND VGND VPWR VPWR _643_/Q sky130_fd_sc_hd__dfrtp_2
XFILLER_11_3 VGND VGND VPWR VPWR sky130_fd_sc_hd__decap_3
XFILLER_39_204 VGND VGND VPWR VPWR sky130_fd_sc_hd__decap_3
XFILLER_22_137 VGND VGND VPWR VPWR sky130_fd_sc_hd__decap_3
XFILLER_22_159 VGND VGND VPWR VPWR sky130_fd_sc_hd__decap_3
XFILLER_30_192 VGND VGND VPWR VPWR sky130_fd_sc_hd__decap_3
XFILLER_30_181 VGND VGND VPWR VPWR sky130_fd_sc_hd__decap_3
XFILLER_13_104 VGND VGND VPWR VPWR sky130_fd_sc_hd__decap_3
XFILLER_26_12 VGND VGND VPWR VPWR sky130_fd_sc_hd__decap_3
XFILLER_26_56 VGND VGND VPWR VPWR sky130_fd_sc_hd__fill_1
XFILLER_13_159 VGND VGND VPWR VPWR sky130_fd_sc_hd__decap_3
Xjam_digital_top VGND VGND VPWR VPWR jam_digital_top/HI hour_tens_o[1] sky130_fd_sc_hd__conb_1
XFILLER_3_27 VGND VGND VPWR VPWR sky130_fd_sc_hd__decap_3
X_557_ _669_/Q _668_/Q _670_/Q VGND VGND VPWR VPWR _561_/B sky130_fd_sc_hd__and3_2
X_626_ _665_/CLK _626_/D _628_/SET_B VGND VGND VPWR VPWR _626_/Q sky130_fd_sc_hd__dfstp_2
X_488_ _506_/B _493_/C VGND VGND VPWR VPWR _489_/C sky130_fd_sc_hd__nand2_2
XTAP_TAPCELL_ROW_14_143 VGND VPWR sky130_fd_sc_hd__tapvpwrvgnd_1
XFILLER_8_141 VGND VGND VPWR VPWR sky130_fd_sc_hd__decap_3
XFILLER_27_218 VGND VGND VPWR VPWR sky130_fd_sc_hd__decap_3
XTAP_TAPCELL_ROW_37_235 VGND VPWR sky130_fd_sc_hd__tapvpwrvgnd_1
Xhold130 _514_/Y VGND VGND VPWR VPWR _659_/D sky130_fd_sc_hd__dlygate4sd3_1
Xhold141 _674_/Q VGND VGND VPWR VPWR _578_/A1 sky130_fd_sc_hd__dlygate4sd3_1
Xhold152 _669_/Q VGND VGND VPWR VPWR _555_/A1 sky130_fd_sc_hd__dlygate4sd3_1
XTAP_TAPCELL_ROW_20_168 VGND VPWR sky130_fd_sc_hd__tapvpwrvgnd_1
XFILLER_37_55 VGND VGND VPWR VPWR sky130_fd_sc_hd__fill_1
X_411_ _695_/Q _419_/D VGND VGND VPWR VPWR _413_/A sky130_fd_sc_hd__and2_2
X_342_ _342_/A _342_/B VGND VGND VPWR VPWR _353_/A sky130_fd_sc_hd__nand2_2
XFILLER_5_122 VGND VGND VPWR VPWR sky130_fd_sc_hd__decap_3
XFILLER_5_111 VGND VGND VPWR VPWR sky130_fd_sc_hd__fill_1
XFILLER_5_199 VGND VGND VPWR VPWR sky130_fd_sc_hd__decap_3
XFILLER_5_177 VGND VGND VPWR VPWR sky130_fd_sc_hd__decap_3
X_609_ _680_/Q _681_/Q _682_/Q _604_/A VGND VGND VPWR VPWR _610_/B sky130_fd_sc_hd__a31o_2
XFILLER_23_210 VGND VGND VPWR VPWR sky130_fd_sc_hd__decap_3
XFILLER_23_243 VGND VGND VPWR VPWR sky130_fd_sc_hd__fill_2
XFILLER_2_125 VGND VGND VPWR VPWR sky130_fd_sc_hd__decap_3
XFILLER_2_147 VGND VGND VPWR VPWR sky130_fd_sc_hd__fill_1
XFILLER_14_221 VGND VGND VPWR VPWR sky130_fd_sc_hd__decap_3
Xfanout91 fanout95/X VGND VGND VPWR VPWR fanout91/X sky130_fd_sc_hd__clkdlybuf4s25_1
X_325_ _700_/Q _325_/B _699_/Q _408_/C VGND VGND VPWR VPWR _325_/X sky130_fd_sc_hd__or4b_2
XFILLER_9_15 VGND VGND VPWR VPWR sky130_fd_sc_hd__decap_3
XTAP_TAPCELL_ROW_0_82 VGND VPWR sky130_fd_sc_hd__tapvpwrvgnd_1
XFILLER_20_213 VGND VGND VPWR VPWR sky130_fd_sc_hd__decap_3
XFILLER_18_24 VGND VGND VPWR VPWR sky130_fd_sc_hd__decap_3
XFILLER_34_12 VGND VGND VPWR VPWR sky130_fd_sc_hd__decap_3
Xclkload0 _653_/CLK VGND VGND VPWR VPWR clkload0/X sky130_fd_sc_hd__clkbuf_4
XFILLER_7_228 VGND VGND VPWR VPWR sky130_fd_sc_hd__fill_1
Xload_slew89 fanout88/X VGND VGND VPWR VPWR load_slew89/X sky130_fd_sc_hd__buf_4
X_308_ _308_/A VGND VGND VPWR VPWR _308_/Y sky130_fd_sc_hd__inv_2
XFILLER_1_60 VGND VGND VPWR VPWR sky130_fd_sc_hd__decap_3
XFILLER_37_121 VGND VGND VPWR VPWR sky130_fd_sc_hd__decap_3
XFILLER_20_36 VGND VGND VPWR VPWR sky130_fd_sc_hd__decap_3
XFILLER_4_209 VGND VGND VPWR VPWR sky130_fd_sc_hd__decap_3
XFILLER_20_69 VGND VGND VPWR VPWR sky130_fd_sc_hd__decap_3
XFILLER_29_12 VGND VGND VPWR VPWR sky130_fd_sc_hd__decap_3
X_590_ _590_/A1 _586_/X _589_/X VGND VGND VPWR VPWR _677_/D sky130_fd_sc_hd__o21ba_2
XFILLER_10_91 VGND VGND VPWR VPWR sky130_fd_sc_hd__decap_3
XFILLER_6_38 VGND VGND VPWR VPWR sky130_fd_sc_hd__decap_3
XFILLER_6_27 VGND VGND VPWR VPWR sky130_fd_sc_hd__fill_1
XFILLER_19_110 VGND VGND VPWR VPWR sky130_fd_sc_hd__fill_2
XFILLER_19_165 VGND VGND VPWR VPWR sky130_fd_sc_hd__decap_3
XFILLER_19_187 VGND VGND VPWR VPWR sky130_fd_sc_hd__decap_3
XFILLER_34_135 VGND VGND VPWR VPWR sky130_fd_sc_hd__decap_3
XFILLER_25_113 VGND VGND VPWR VPWR sky130_fd_sc_hd__decap_3
XFILLER_15_36 VGND VGND VPWR VPWR sky130_fd_sc_hd__decap_3
XFILLER_15_69 VGND VGND VPWR VPWR sky130_fd_sc_hd__decap_3
XFILLER_33_190 VGND VGND VPWR VPWR sky130_fd_sc_hd__decap_3
XFILLER_31_24 VGND VGND VPWR VPWR sky130_fd_sc_hd__decap_3
Xoutput57 _676_/Q VGND VGND VPWR VPWR sec_tens_o[0] sky130_fd_sc_hd__clkdlybuf4s25_1
Xoutput46 _674_/Q VGND VGND VPWR VPWR min_ones_o[2] sky130_fd_sc_hd__clkdlybuf4s25_1
Xoutput35 _632_/Q VGND VGND VPWR VPWR digit_sel_o[2] sky130_fd_sc_hd__clkdlybuf4s25_1
XFILLER_31_68 VGND VGND VPWR VPWR sky130_fd_sc_hd__fill_1
XFILLER_31_57 VGND VGND VPWR VPWR sky130_fd_sc_hd__decap_3
XFILLER_0_234 VGND VGND VPWR VPWR sky130_fd_sc_hd__decap_3
X_642_ _642_/CLK _642_/D load_slew83/X VGND VGND VPWR VPWR _642_/Q sky130_fd_sc_hd__dfrtp_2
X_711_ _711_/CLK _711_/D load_slew87/X VGND VGND VPWR VPWR _711_/Q sky130_fd_sc_hd__dfrtp_2
Xoutput68 _704_/Q VGND VGND VPWR VPWR tick_1hz_o sky130_fd_sc_hd__clkdlybuf4s25_1
XFILLER_16_102 VGND VGND VPWR VPWR sky130_fd_sc_hd__decap_3
XFILLER_16_168 VGND VGND VPWR VPWR sky130_fd_sc_hd__decap_3
X_573_ _573_/A0 _572_/X _573_/S VGND VGND VPWR VPWR _673_/D sky130_fd_sc_hd__mux2_1
XPHY_EDGE_ROW_19_Right_19 VGND VGND VPWR VPWR sky130_fd_sc_hd__decap_3
XPHY_EDGE_ROW_28_Right_28 VGND VGND VPWR VPWR sky130_fd_sc_hd__decap_3
XFILLER_39_216 VGND VGND VPWR VPWR sky130_fd_sc_hd__decap_3
XPHY_EDGE_ROW_37_Right_37 VGND VGND VPWR VPWR sky130_fd_sc_hd__decap_3
XFILLER_30_171 VGND VGND VPWR VPWR sky130_fd_sc_hd__fill_2
XFILLER_13_116 VGND VGND VPWR VPWR sky130_fd_sc_hd__decap_3
XFILLER_13_138 VGND VGND VPWR VPWR sky130_fd_sc_hd__decap_3
XTAP_TAPCELL_ROW_8_120 VGND VPWR sky130_fd_sc_hd__tapvpwrvgnd_1
XFILLER_3_39 VGND VGND VPWR VPWR sky130_fd_sc_hd__decap_3
X_625_ _665_/CLK _625_/D _628_/SET_B VGND VGND VPWR VPWR _625_/Q sky130_fd_sc_hd__dfstp_2
X_556_ _556_/A _556_/B VGND VGND VPWR VPWR _556_/X sky130_fd_sc_hd__and2_2
X_487_ _650_/Q _651_/Q _485_/C _652_/Q VGND VGND VPWR VPWR _489_/B sky130_fd_sc_hd__a31o_2
XTAP_TAPCELL_ROW_14_144 VGND VPWR sky130_fd_sc_hd__tapvpwrvgnd_1
XFILLER_12_193 VGND VGND VPWR VPWR sky130_fd_sc_hd__decap_3
XFILLER_8_197 VGND VGND VPWR VPWR sky130_fd_sc_hd__decap_3
XFILLER_8_153 VGND VGND VPWR VPWR sky130_fd_sc_hd__decap_3
XTAP_TAPCELL_ROW_37_236 VGND VPWR sky130_fd_sc_hd__tapvpwrvgnd_1
XFILLER_12_37 VGND VGND VPWR VPWR sky130_fd_sc_hd__decap_3
XTAP_TAPCELL_ROW_20_169 VGND VPWR sky130_fd_sc_hd__tapvpwrvgnd_1
Xhold120 _695_/Q VGND VGND VPWR VPWR _412_/A1 sky130_fd_sc_hd__dlygate4sd3_1
Xhold131 _688_/Q VGND VGND VPWR VPWR _394_/A2 sky130_fd_sc_hd__dlygate4sd3_1
Xhold142 _673_/Q VGND VGND VPWR VPWR _573_/A0 sky130_fd_sc_hd__dlygate4sd3_1
Xhold153 _697_/Q VGND VGND VPWR VPWR _416_/B1 sky130_fd_sc_hd__dlygate4sd3_1
XFILLER_5_9 VGND VGND VPWR VPWR sky130_fd_sc_hd__decap_3
XFILLER_37_12 VGND VGND VPWR VPWR sky130_fd_sc_hd__decap_3
X_410_ _308_/Y _407_/C _409_/Y VGND VGND VPWR VPWR _410_/Y sky130_fd_sc_hd__a21boi_2
X_341_ _341_/A _341_/B _341_/C VGND VGND VPWR VPWR _342_/B sky130_fd_sc_hd__nor3_2
XFILLER_5_156 VGND VGND VPWR VPWR sky130_fd_sc_hd__decap_3
XFILLER_5_134 VGND VGND VPWR VPWR sky130_fd_sc_hd__fill_1
X_608_ _680_/Q _681_/Q _682_/Q VGND VGND VPWR VPWR _608_/X sky130_fd_sc_hd__a21o_2
XFILLER_32_200 VGND VGND VPWR VPWR sky130_fd_sc_hd__fill_1
X_539_ _665_/Q _664_/Q _666_/Q _667_/Q _435_/C VGND VGND VPWR VPWR _540_/A sky130_fd_sc_hd__a41o_2
XFILLER_32_244 VGND VGND VPWR VPWR sky130_fd_sc_hd__fill_1
XFILLER_2_137 VGND VGND VPWR VPWR sky130_fd_sc_hd__decap_3
XFILLER_3_6 VGND VGND VPWR VPWR sky130_fd_sc_hd__decap_3
XFILLER_0_18 VGND VGND VPWR VPWR sky130_fd_sc_hd__decap_3
XFILLER_0_29 VGND VGND VPWR VPWR sky130_fd_sc_hd__decap_3
Xfanout81 input6/X VGND VGND VPWR VPWR _542_/A1 sky130_fd_sc_hd__clkdlybuf4s25_1
X_324_ _701_/Q _702_/Q VGND VGND VPWR VPWR _325_/B sky130_fd_sc_hd__nand2_2
XTAP_TAPCELL_ROW_0_83 VGND VPWR sky130_fd_sc_hd__tapvpwrvgnd_1
XFILLER_36_6 VGND VGND VPWR VPWR sky130_fd_sc_hd__decap_3
XFILLER_18_14 VGND VGND VPWR VPWR sky130_fd_sc_hd__fill_2
XFILLER_11_225 VGND VGND VPWR VPWR sky130_fd_sc_hd__decap_3
Xclkload1 _713_/CLK VGND VGND VPWR VPWR clkload1/X sky130_fd_sc_hd__clkbuf_4
XFILLER_34_24 VGND VGND VPWR VPWR sky130_fd_sc_hd__decap_3
XFILLER_1_3 VGND VGND VPWR VPWR sky130_fd_sc_hd__decap_3
XFILLER_34_3 VGND VGND VPWR VPWR sky130_fd_sc_hd__decap_3
XFILLER_1_94 VGND VGND VPWR VPWR sky130_fd_sc_hd__decap_3
XFILLER_37_100 VGND VGND VPWR VPWR sky130_fd_sc_hd__decap_3
XFILLER_20_15 VGND VGND VPWR VPWR sky130_fd_sc_hd__decap_3
XFILLER_20_48 VGND VGND VPWR VPWR sky130_fd_sc_hd__decap_3
XFILLER_28_100 VGND VGND VPWR VPWR sky130_fd_sc_hd__fill_2
XFILLER_29_24 VGND VGND VPWR VPWR sky130_fd_sc_hd__fill_1
XFILLER_29_57 VGND VGND VPWR VPWR sky130_fd_sc_hd__decap_3
XFILLER_29_79 VGND VGND VPWR VPWR sky130_fd_sc_hd__decap_3
XFILLER_28_144 VGND VGND VPWR VPWR sky130_fd_sc_hd__decap_3
XFILLER_28_166 VGND VGND VPWR VPWR sky130_fd_sc_hd__decap_3
XFILLER_3_210 VGND VGND VPWR VPWR sky130_fd_sc_hd__decap_3
XFILLER_19_100 VGND VGND VPWR VPWR sky130_fd_sc_hd__decap_3
XFILLER_20_9 VGND VGND VPWR VPWR sky130_fd_sc_hd__decap_3
XFILLER_34_114 VGND VGND VPWR VPWR sky130_fd_sc_hd__decap_3
XFILLER_34_147 VGND VGND VPWR VPWR sky130_fd_sc_hd__decap_3
XFILLER_15_15 VGND VGND VPWR VPWR sky130_fd_sc_hd__decap_3
XFILLER_25_103 VGND VGND VPWR VPWR sky130_fd_sc_hd__decap_3
XFILLER_25_169 VGND VGND VPWR VPWR sky130_fd_sc_hd__decap_3
XFILLER_31_36 VGND VGND VPWR VPWR sky130_fd_sc_hd__decap_3
Xoutput58 _677_/Q VGND VGND VPWR VPWR sec_tens_o[1] sky130_fd_sc_hd__clkdlybuf4s25_1
Xoutput47 _675_/Q VGND VGND VPWR VPWR min_ones_o[3] sky130_fd_sc_hd__clkdlybuf4s25_1
Xoutput36 _633_/Q VGND VGND VPWR VPWR digit_sel_o[3] sky130_fd_sc_hd__clkdlybuf4s25_1
X_572_ _545_/Y _570_/X _576_/B _569_/X VGND VGND VPWR VPWR _572_/X sky130_fd_sc_hd__a31o_2
X_641_ _642_/CLK _641_/D load_slew83/X VGND VGND VPWR VPWR _641_/Q sky130_fd_sc_hd__dfrtp_2
X_710_ _713_/CLK _710_/D load_slew92/X VGND VGND VPWR VPWR _710_/Q sky130_fd_sc_hd__dfrtp_2
XFILLER_16_125 VGND VGND VPWR VPWR sky130_fd_sc_hd__decap_3
XFILLER_21_80 VGND VGND VPWR VPWR sky130_fd_sc_hd__decap_3
XFILLER_39_228 VGND VGND VPWR VPWR sky130_fd_sc_hd__decap_3
XFILLER_30_150 VGND VGND VPWR VPWR sky130_fd_sc_hd__fill_2
XTAP_TAPCELL_ROW_23_178 VGND VPWR sky130_fd_sc_hd__tapvpwrvgnd_1
XTAP_TAPCELL_ROW_8_121 VGND VPWR sky130_fd_sc_hd__tapvpwrvgnd_1
XFILLER_3_18 VGND VGND VPWR VPWR sky130_fd_sc_hd__decap_3
X_555_ _555_/A1 _551_/X _554_/Y _550_/A VGND VGND VPWR VPWR _669_/D sky130_fd_sc_hd__o22a_2
X_624_ _670_/CLK _624_/D _628_/SET_B VGND VGND VPWR VPWR _624_/Q sky130_fd_sc_hd__dfstp_2
XFILLER_16_91 VGND VGND VPWR VPWR sky130_fd_sc_hd__fill_2
X_486_ _522_/A _486_/B _486_/C VGND VGND VPWR VPWR _651_/D sky130_fd_sc_hd__and3_2
XTAP_TAPCELL_ROW_14_145 VGND VPWR sky130_fd_sc_hd__tapvpwrvgnd_1
XFILLER_8_165 VGND VGND VPWR VPWR sky130_fd_sc_hd__fill_2
XTAP_TAPCELL_ROW_37_237 VGND VPWR sky130_fd_sc_hd__tapvpwrvgnd_1
XFILLER_35_242 VGND VGND VPWR VPWR sky130_fd_sc_hd__decap_3
XFILLER_10_109 VGND VGND VPWR VPWR sky130_fd_sc_hd__decap_3
XFILLER_12_27 VGND VGND VPWR VPWR sky130_fd_sc_hd__fill_1
Xhold110 _707_/Q VGND VGND VPWR VPWR _710_/D sky130_fd_sc_hd__dlygate4sd3_1
Xhold121 _413_/Y VGND VGND VPWR VPWR _695_/D sky130_fd_sc_hd__dlygate4sd3_1
Xhold132 _394_/X VGND VGND VPWR VPWR _688_/D sky130_fd_sc_hd__dlygate4sd3_1
Xhold143 _656_/Q VGND VGND VPWR VPWR _502_/A1 sky130_fd_sc_hd__dlygate4sd3_1
Xhold154 _645_/Q VGND VGND VPWR VPWR _315_/A sky130_fd_sc_hd__dlygate4sd3_1
XFILLER_37_57 VGND VGND VPWR VPWR sky130_fd_sc_hd__fill_2
XFILLER_37_24 VGND VGND VPWR VPWR sky130_fd_sc_hd__fill_2
X_340_ _670_/Q _633_/D _333_/Y _674_/Q VGND VGND VPWR VPWR _341_/C sky130_fd_sc_hd__a22o_2
XFILLER_5_113 VGND VGND VPWR VPWR sky130_fd_sc_hd__decap_3
XFILLER_5_102 VGND VGND VPWR VPWR sky130_fd_sc_hd__decap_3
X_538_ _532_/S _534_/X _667_/Q VGND VGND VPWR VPWR _538_/X sky130_fd_sc_hd__a21o_2
X_607_ _614_/B _605_/X _606_/Y _607_/B2 VGND VGND VPWR VPWR _681_/D sky130_fd_sc_hd__a22o_2
XFILLER_32_212 VGND VGND VPWR VPWR sky130_fd_sc_hd__decap_3
X_469_ _646_/Q _647_/Q _469_/C VGND VGND VPWR VPWR _469_/Y sky130_fd_sc_hd__nand3_2
XFILLER_4_50 VGND VGND VPWR VPWR sky130_fd_sc_hd__decap_3
XFILLER_2_116 VGND VGND VPWR VPWR sky130_fd_sc_hd__decap_3
XFILLER_13_70 VGND VGND VPWR VPWR sky130_fd_sc_hd__decap_3
Xfanout82 input31/X VGND VGND VPWR VPWR fanout82/X sky130_fd_sc_hd__clkdlybuf4s25_1
Xfanout93 fanout95/X VGND VGND VPWR VPWR fanout93/X sky130_fd_sc_hd__clkdlybuf4s25_1
X_323_ _692_/Q _691_/Q _323_/C _419_/C VGND VGND VPWR VPWR _323_/X sky130_fd_sc_hd__or4b_2
XFILLER_29_6 VGND VGND VPWR VPWR sky130_fd_sc_hd__decap_3
XTAP_TAPCELL_ROW_0_84 VGND VPWR sky130_fd_sc_hd__tapvpwrvgnd_1
Xclkload2 _642_/CLK VGND VGND VPWR VPWR clkload2/X sky130_fd_sc_hd__clkbuf_4
XFILLER_7_219 VGND VGND VPWR VPWR sky130_fd_sc_hd__decap_3
XFILLER_34_58 VGND VGND VPWR VPWR sky130_fd_sc_hd__fill_1
XPHY_EDGE_ROW_28_Left_69 VGND VGND VPWR VPWR sky130_fd_sc_hd__decap_3
XFILLER_1_51 VGND VGND VPWR VPWR sky130_fd_sc_hd__decap_3
XFILLER_37_167 VGND VGND VPWR VPWR sky130_fd_sc_hd__fill_1
XFILLER_20_27 VGND VGND VPWR VPWR sky130_fd_sc_hd__fill_1
XFILLER_28_178 VGND VGND VPWR VPWR sky130_fd_sc_hd__decap_3
XFILLER_6_29 VGND VGND VPWR VPWR sky130_fd_sc_hd__decap_3
XFILLER_6_18 VGND VGND VPWR VPWR sky130_fd_sc_hd__decap_3
XFILLER_10_82 VGND VGND VPWR VPWR sky130_fd_sc_hd__fill_2
XFILLER_13_9 VGND VGND VPWR VPWR sky130_fd_sc_hd__fill_2
XFILLER_19_123 VGND VGND VPWR VPWR sky130_fd_sc_hd__decap_3
XFILLER_19_156 VGND VGND VPWR VPWR sky130_fd_sc_hd__decap_3
XFILLER_19_178 VGND VGND VPWR VPWR sky130_fd_sc_hd__decap_3
XFILLER_19_91 VGND VGND VPWR VPWR sky130_fd_sc_hd__decap_3
XFILLER_34_126 VGND VGND VPWR VPWR sky130_fd_sc_hd__decap_3
XFILLER_34_159 VGND VGND VPWR VPWR sky130_fd_sc_hd__fill_2
XFILLER_15_27 VGND VGND VPWR VPWR sky130_fd_sc_hd__fill_2
XFILLER_31_48 VGND VGND VPWR VPWR sky130_fd_sc_hd__decap_3
XFILLER_31_15 VGND VGND VPWR VPWR sky130_fd_sc_hd__decap_3
XFILLER_0_225 VGND VGND VPWR VPWR sky130_fd_sc_hd__decap_3
Xoutput59 _678_/Q VGND VGND VPWR VPWR sec_tens_o[2] sky130_fd_sc_hd__clkdlybuf4s25_1
Xoutput48 _668_/Q VGND VGND VPWR VPWR min_tens_o[0] sky130_fd_sc_hd__clkdlybuf4s25_1
Xoutput37 _634_/Q VGND VGND VPWR VPWR digit_sel_o[4] sky130_fd_sc_hd__clkdlybuf4s25_1
XPHY_EDGE_ROW_1_Right_1 VGND VGND VPWR VPWR sky130_fd_sc_hd__decap_3
XFILLER_16_115 VGND VGND VPWR VPWR sky130_fd_sc_hd__fill_2
XFILLER_16_137 VGND VGND VPWR VPWR sky130_fd_sc_hd__decap_3
X_571_ _672_/Q _673_/Q VGND VGND VPWR VPWR _576_/B sky130_fd_sc_hd__nand2_2
X_640_ _642_/CLK _640_/D load_slew83/X VGND VGND VPWR VPWR _640_/Q sky130_fd_sc_hd__dfrtp_2
XFILLER_24_192 VGND VGND VPWR VPWR sky130_fd_sc_hd__decap_3
XFILLER_21_92 VGND VGND VPWR VPWR sky130_fd_sc_hd__decap_3
XFILLER_11_6 VGND VGND VPWR VPWR sky130_fd_sc_hd__fill_2
XFILLER_39_207 VGND VGND VPWR VPWR sky130_fd_sc_hd__decap_3
XTAP_TAPCELL_ROW_17_154 VGND VPWR sky130_fd_sc_hd__tapvpwrvgnd_1
XFILLER_7_72 VGND VGND VPWR VPWR sky130_fd_sc_hd__decap_3
XFILLER_30_195 VGND VGND VPWR VPWR sky130_fd_sc_hd__fill_1
XFILLER_30_162 VGND VGND VPWR VPWR sky130_fd_sc_hd__decap_3
XPHY_EDGE_ROW_15_Left_56 VGND VGND VPWR VPWR sky130_fd_sc_hd__decap_3
XFILLER_26_15 VGND VGND VPWR VPWR sky130_fd_sc_hd__decap_3
XFILLER_13_107 VGND VGND VPWR VPWR sky130_fd_sc_hd__decap_3
XTAP_TAPCELL_ROW_23_179 VGND VPWR sky130_fd_sc_hd__tapvpwrvgnd_1
XFILLER_16_70 VGND VGND VPWR VPWR sky130_fd_sc_hd__decap_3
X_554_ _372_/X _556_/B _552_/X VGND VGND VPWR VPWR _554_/Y sky130_fd_sc_hd__o21ai_2
X_623_ _670_/CLK _623_/D _628_/SET_B VGND VGND VPWR VPWR _623_/Q sky130_fd_sc_hd__dfstp_2
X_485_ _650_/Q _651_/Q _485_/C VGND VGND VPWR VPWR _486_/C sky130_fd_sc_hd__nand3_2
XFILLER_8_144 VGND VGND VPWR VPWR sky130_fd_sc_hd__decap_3
Xhold111 _639_/Q VGND VGND VPWR VPWR _446_/A1 sky130_fd_sc_hd__dlygate4sd3_1
Xhold122 _689_/Q VGND VGND VPWR VPWR _395_/B1 sky130_fd_sc_hd__dlygate4sd3_1
Xhold133 _700_/Q VGND VGND VPWR VPWR _427_/A1 sky130_fd_sc_hd__dlygate4sd3_1
Xhold144 _641_/Q VGND VGND VPWR VPWR _453_/A1 sky130_fd_sc_hd__dlygate4sd3_1
Xhold155 _647_/Q VGND VGND VPWR VPWR _472_/A1 sky130_fd_sc_hd__dlygate4sd3_1
XFILLER_26_210 VGND VGND VPWR VPWR sky130_fd_sc_hd__fill_2
XFILLER_5_125 VGND VGND VPWR VPWR sky130_fd_sc_hd__decap_3
X_537_ _666_/Q _532_/S _533_/X _536_/Y VGND VGND VPWR VPWR _666_/D sky130_fd_sc_hd__o22a_2
X_606_ _604_/A _680_/Q _614_/B VGND VGND VPWR VPWR _606_/Y sky130_fd_sc_hd__o21ai_2
X_468_ _468_/A1 _469_/C _467_/Y VGND VGND VPWR VPWR _646_/D sky130_fd_sc_hd__a21oi_2
X_399_ _400_/A1 _408_/C _407_/A VGND VGND VPWR VPWR _399_/Y sky130_fd_sc_hd__o21ai_2
XFILLER_4_62 VGND VGND VPWR VPWR sky130_fd_sc_hd__fill_2
XFILLER_4_180 VGND VGND VPWR VPWR sky130_fd_sc_hd__fill_1
XFILLER_23_213 VGND VGND VPWR VPWR sky130_fd_sc_hd__decap_3
XFILLER_2_128 VGND VGND VPWR VPWR sky130_fd_sc_hd__decap_3
X_322_ _695_/Q _696_/Q VGND VGND VPWR VPWR _419_/C sky130_fd_sc_hd__and2_2
XFILLER_9_18 VGND VGND VPWR VPWR sky130_fd_sc_hd__fill_2
Xfanout72 _499_/B VGND VGND VPWR VPWR _458_/A sky130_fd_sc_hd__clkdlybuf4s25_1
XTAP_TAPCELL_ROW_0_85 VGND VPWR sky130_fd_sc_hd__tapvpwrvgnd_1
XFILLER_20_216 VGND VGND VPWR VPWR sky130_fd_sc_hd__fill_2
XFILLER_18_27 VGND VGND VPWR VPWR sky130_fd_sc_hd__fill_1
XFILLER_34_37 VGND VGND VPWR VPWR sky130_fd_sc_hd__fill_1
XFILLER_34_15 VGND VGND VPWR VPWR sky130_fd_sc_hd__decap_3
Xclkload3 _684_/CLK VGND VGND VPWR VPWR clkload3/X sky130_fd_sc_hd__clkbuf_4
XPHY_EDGE_ROW_3_Left_44 VGND VGND VPWR VPWR sky130_fd_sc_hd__decap_3
XFILLER_1_30 VGND VGND VPWR VPWR sky130_fd_sc_hd__decap_3
XFILLER_37_124 VGND VGND VPWR VPWR sky130_fd_sc_hd__decap_3
XFILLER_1_63 VGND VGND VPWR VPWR sky130_fd_sc_hd__decap_3
XFILLER_20_39 VGND VGND VPWR VPWR sky130_fd_sc_hd__decap_3
XFILLER_29_15 VGND VGND VPWR VPWR sky130_fd_sc_hd__decap_3
XFILLER_28_113 VGND VGND VPWR VPWR sky130_fd_sc_hd__decap_3
XFILLER_28_124 VGND VGND VPWR VPWR sky130_fd_sc_hd__decap_3
XFILLER_3_223 VGND VGND VPWR VPWR sky130_fd_sc_hd__fill_1
XFILLER_10_94 VGND VGND VPWR VPWR sky130_fd_sc_hd__decap_3
XFILLER_34_138 VGND VGND VPWR VPWR sky130_fd_sc_hd__fill_2
XFILLER_15_39 VGND VGND VPWR VPWR sky130_fd_sc_hd__decap_3
XFILLER_25_116 VGND VGND VPWR VPWR sky130_fd_sc_hd__fill_1
XFILLER_33_193 VGND VGND VPWR VPWR sky130_fd_sc_hd__decap_3
XFILLER_31_27 VGND VGND VPWR VPWR sky130_fd_sc_hd__decap_3
Xoutput49 _669_/Q VGND VGND VPWR VPWR min_tens_o[1] sky130_fd_sc_hd__clkdlybuf4s25_1
Xoutput38 _635_/Q VGND VGND VPWR VPWR digit_sel_o[5] sky130_fd_sc_hd__clkdlybuf4s25_1
XFILLER_16_105 VGND VGND VPWR VPWR sky130_fd_sc_hd__fill_2
X_570_ _672_/Q _673_/Q VGND VGND VPWR VPWR _570_/X sky130_fd_sc_hd__or2_2
XFILLER_21_60 VGND VGND VPWR VPWR sky130_fd_sc_hd__decap_3
XFILLER_21_71 VGND VGND VPWR VPWR sky130_fd_sc_hd__fill_2
XFILLER_39_219 VGND VGND VPWR VPWR sky130_fd_sc_hd__decap_3
X_699_ _711_/CLK _699_/D fanout86/X VGND VGND VPWR VPWR _699_/Q sky130_fd_sc_hd__dfrtp_2
Xclkbuf_0_clk clk VGND VGND VPWR VPWR clkbuf_0_clk/X sky130_fd_sc_hd__clkbuf_16
XTAP_TAPCELL_ROW_17_155 VGND VPWR sky130_fd_sc_hd__tapvpwrvgnd_1
XFILLER_7_51 VGND VGND VPWR VPWR sky130_fd_sc_hd__decap_3
XFILLER_30_141 VGND VGND VPWR VPWR sky130_fd_sc_hd__decap_3
XPHY_EDGE_ROW_15_Right_15 VGND VGND VPWR VPWR sky130_fd_sc_hd__decap_3
XPHY_EDGE_ROW_24_Right_24 VGND VGND VPWR VPWR sky130_fd_sc_hd__decap_3
XFILLER_13_119 VGND VGND VPWR VPWR sky130_fd_sc_hd__decap_3
XPHY_EDGE_ROW_33_Right_33 VGND VGND VPWR VPWR sky130_fd_sc_hd__decap_3
X_622_ _667_/CLK _622_/D fanout91/X VGND VGND VPWR VPWR _622_/Q sky130_fd_sc_hd__dfrtp_2
X_553_ _669_/Q _668_/Q _574_/C VGND VGND VPWR VPWR _556_/B sky130_fd_sc_hd__a21o_2
X_484_ _650_/Q _649_/Q _493_/C _651_/Q VGND VGND VPWR VPWR _486_/B sky130_fd_sc_hd__a31o_2
XPHY_EDGE_ROW_32_Left_73 VGND VGND VPWR VPWR sky130_fd_sc_hd__decap_3
XFILLER_12_141 VGND VGND VPWR VPWR sky130_fd_sc_hd__decap_3
XFILLER_8_156 VGND VGND VPWR VPWR sky130_fd_sc_hd__fill_2
XFILLER_35_222 VGND VGND VPWR VPWR sky130_fd_sc_hd__fill_2
Xhold112 _663_/Q VGND VGND VPWR VPWR _523_/A sky130_fd_sc_hd__dlygate4sd3_1
Xhold123 _395_/Y VGND VGND VPWR VPWR _396_/C sky130_fd_sc_hd__dlygate4sd3_1
Xhold134 _427_/Y VGND VGND VPWR VPWR _700_/D sky130_fd_sc_hd__dlygate4sd3_1
Xhold145 _677_/Q VGND VGND VPWR VPWR _590_/A1 sky130_fd_sc_hd__dlygate4sd3_1
Xhold156 _681_/Q VGND VGND VPWR VPWR _607_/B2 sky130_fd_sc_hd__dlygate4sd3_1
XFILLER_37_15 VGND VGND VPWR VPWR sky130_fd_sc_hd__decap_3
XFILLER_26_233 VGND VGND VPWR VPWR sky130_fd_sc_hd__decap_3
XFILLER_5_159 VGND VGND VPWR VPWR sky130_fd_sc_hd__fill_2
X_605_ _605_/A1 _603_/Y _604_/X VGND VGND VPWR VPWR _605_/X sky130_fd_sc_hd__a21bo_2
X_536_ _534_/X _535_/Y _532_/S VGND VGND VPWR VPWR _536_/Y sky130_fd_sc_hd__o21ai_2
X_467_ _468_/A1 _469_/C _458_/A VGND VGND VPWR VPWR _467_/Y sky130_fd_sc_hd__o21ai_2
X_398_ _398_/A1 _396_/B _397_/Y VGND VGND VPWR VPWR _690_/D sky130_fd_sc_hd__o21a_2
XFILLER_4_96 VGND VGND VPWR VPWR sky130_fd_sc_hd__decap_3
XFILLER_4_85 VGND VGND VPWR VPWR sky130_fd_sc_hd__decap_3
XFILLER_4_41 VGND VGND VPWR VPWR sky130_fd_sc_hd__decap_3
XFILLER_23_225 VGND VGND VPWR VPWR sky130_fd_sc_hd__fill_2
XTAP_TAPCELL_ROW_33_220 VGND VPWR sky130_fd_sc_hd__tapvpwrvgnd_1
XFILLER_3_9 VGND VGND VPWR VPWR sky130_fd_sc_hd__decap_3
Xfanout73 _603_/A VGND VGND VPWR VPWR _552_/A sky130_fd_sc_hd__clkdlybuf4s25_1
X_321_ _694_/Q _698_/Q _697_/Q _693_/Q VGND VGND VPWR VPWR _323_/C sky130_fd_sc_hd__or4b_2
Xfanout84 input31/X VGND VGND VPWR VPWR fanout84/X sky130_fd_sc_hd__clkdlybuf4s25_1
Xfanout95 fanout98/A VGND VGND VPWR VPWR fanout95/X sky130_fd_sc_hd__clkdlybuf4s25_1
XFILLER_1_140 VGND VGND VPWR VPWR sky130_fd_sc_hd__decap_3
XTAP_TAPCELL_ROW_0_86 VGND VPWR sky130_fd_sc_hd__tapvpwrvgnd_1
XFILLER_36_9 VGND VGND VPWR VPWR sky130_fd_sc_hd__decap_3
Xclkload10 _712_/CLK VGND VGND VPWR VPWR clkload10/X sky130_fd_sc_hd__clkbuf_4
X_519_ _519_/A _519_/B VGND VGND VPWR VPWR _661_/D sky130_fd_sc_hd__nor2_2
XFILLER_11_217 VGND VGND VPWR VPWR sky130_fd_sc_hd__fill_2
XFILLER_11_228 VGND VGND VPWR VPWR sky130_fd_sc_hd__fill_1
XFILLER_34_49 VGND VGND VPWR VPWR sky130_fd_sc_hd__decap_3
XFILLER_34_27 VGND VGND VPWR VPWR sky130_fd_sc_hd__fill_1
Xclkload4 _667_/CLK VGND VGND VPWR VPWR clkload4/X sky130_fd_sc_hd__clkbuf_4
XFILLER_1_6 VGND VGND VPWR VPWR sky130_fd_sc_hd__decap_3
XFILLER_24_93 VGND VGND VPWR VPWR sky130_fd_sc_hd__decap_3
XFILLER_40_81 VGND VGND VPWR VPWR sky130_fd_sc_hd__decap_3
XFILLER_1_42 VGND VGND VPWR VPWR sky130_fd_sc_hd__decap_3
XFILLER_37_103 VGND VGND VPWR VPWR sky130_fd_sc_hd__fill_1
XFILLER_34_6 VGND VGND VPWR VPWR sky130_fd_sc_hd__decap_3
XFILLER_1_97 VGND VGND VPWR VPWR sky130_fd_sc_hd__decap_3
XFILLER_37_169 VGND VGND VPWR VPWR sky130_fd_sc_hd__fill_1
XFILLER_37_158 VGND VGND VPWR VPWR sky130_fd_sc_hd__fill_2
XFILLER_20_18 VGND VGND VPWR VPWR sky130_fd_sc_hd__decap_3
XFILLER_28_147 VGND VGND VPWR VPWR sky130_fd_sc_hd__decap_3
XFILLER_28_169 VGND VGND VPWR VPWR sky130_fd_sc_hd__decap_3
XFILLER_36_191 VGND VGND VPWR VPWR sky130_fd_sc_hd__decap_3
XFILLER_3_213 VGND VGND VPWR VPWR sky130_fd_sc_hd__fill_1
XFILLER_19_60 VGND VGND VPWR VPWR sky130_fd_sc_hd__decap_3
XFILLER_19_169 VGND VGND VPWR VPWR sky130_fd_sc_hd__decap_3
XFILLER_34_117 VGND VGND VPWR VPWR sky130_fd_sc_hd__decap_3
XFILLER_32_3 VGND VGND VPWR VPWR sky130_fd_sc_hd__decap_3
XFILLER_25_106 VGND VGND VPWR VPWR sky130_fd_sc_hd__decap_3
XFILLER_15_18 VGND VGND VPWR VPWR sky130_fd_sc_hd__decap_3
XFILLER_33_150 VGND VGND VPWR VPWR sky130_fd_sc_hd__decap_3
Xoutput39 _664_/Q VGND VGND VPWR VPWR hour_ones_o[0] sky130_fd_sc_hd__clkdlybuf4s25_1
XFILLER_31_39 VGND VGND VPWR VPWR sky130_fd_sc_hd__decap_3
XFILLER_16_128 VGND VGND VPWR VPWR sky130_fd_sc_hd__decap_3
XFILLER_21_83 VGND VGND VPWR VPWR sky130_fd_sc_hd__decap_3
XFILLER_15_161 VGND VGND VPWR VPWR sky130_fd_sc_hd__decap_3
XFILLER_15_172 VGND VGND VPWR VPWR sky130_fd_sc_hd__fill_1
XFILLER_30_120 VGND VGND VPWR VPWR sky130_fd_sc_hd__decap_3
XFILLER_30_131 VGND VGND VPWR VPWR sky130_fd_sc_hd__fill_1
X_698_ _712_/CLK _698_/D fanout90/X VGND VGND VPWR VPWR _698_/Q sky130_fd_sc_hd__dfrtp_2
Xmax_cap70 _342_/B VGND VGND VPWR VPWR _362_/B sky130_fd_sc_hd__clkbuf_2
XTAP_TAPCELL_ROW_17_156 VGND VPWR sky130_fd_sc_hd__tapvpwrvgnd_1
XFILLER_7_30 VGND VGND VPWR VPWR sky130_fd_sc_hd__decap_3
XFILLER_30_197 VGND VGND VPWR VPWR sky130_fd_sc_hd__decap_3
X_621_ _620_/X _618_/A _686_/Q VGND VGND VPWR VPWR _686_/D sky130_fd_sc_hd__mux2_1
XFILLER_16_61 VGND VGND VPWR VPWR sky130_fd_sc_hd__decap_3
X_552_ _552_/A _552_/B _552_/C _548_/A2 VGND VGND VPWR VPWR _552_/X sky130_fd_sc_hd__or4b_2
X_483_ _522_/A _483_/B _483_/C VGND VGND VPWR VPWR _650_/D sky130_fd_sc_hd__and3_2
XFILLER_12_197 VGND VGND VPWR VPWR sky130_fd_sc_hd__decap_3
XFILLER_32_82 VGND VGND VPWR VPWR sky130_fd_sc_hd__fill_2
XFILLER_32_60 VGND VGND VPWR VPWR sky130_fd_sc_hd__fill_1
Xhold113 _642_/Q VGND VGND VPWR VPWR _455_/A1 sky130_fd_sc_hd__dlygate4sd3_1
Xhold124 _696_/Q VGND VGND VPWR VPWR _415_/A1 sky130_fd_sc_hd__dlygate4sd3_1
Xhold135 _670_/Q VGND VGND VPWR VPWR _560_/A1 sky130_fd_sc_hd__dlygate4sd3_1
Xhold146 _683_/Q VGND VGND VPWR VPWR _615_/A1 sky130_fd_sc_hd__dlygate4sd3_1
Xhold157 _702_/Q VGND VGND VPWR VPWR _430_/C sky130_fd_sc_hd__dlygate4sd3_1
XFILLER_5_116 VGND VGND VPWR VPWR sky130_fd_sc_hd__decap_3
XFILLER_5_105 VGND VGND VPWR VPWR sky130_fd_sc_hd__decap_3
X_535_ _665_/Q _664_/Q _666_/Q VGND VGND VPWR VPWR _535_/Y sky130_fd_sc_hd__a21oi_2
X_604_ _604_/A _681_/Q _614_/A _680_/Q VGND VGND VPWR VPWR _604_/X sky130_fd_sc_hd__or4b_2
X_466_ _315_/Y _464_/C _469_/C _533_/A _448_/A VGND VGND VPWR VPWR _645_/D sky130_fd_sc_hd__a2111oi_2
X_397_ _448_/A _408_/C VGND VGND VPWR VPWR _397_/Y sky130_fd_sc_hd__nor2_2
XFILLER_32_215 VGND VGND VPWR VPWR sky130_fd_sc_hd__decap_3
XFILLER_4_53 VGND VGND VPWR VPWR sky130_fd_sc_hd__decap_3
XTAP_TAPCELL_ROW_33_221 VGND VPWR sky130_fd_sc_hd__tapvpwrvgnd_1
XFILLER_2_119 VGND VGND VPWR VPWR sky130_fd_sc_hd__decap_3
XFILLER_14_215 VGND VGND VPWR VPWR sky130_fd_sc_hd__decap_3
Xfanout74 _542_/A1 VGND VGND VPWR VPWR _534_/B1 sky130_fd_sc_hd__clkdlybuf4s25_1
Xfanout96 fanout98/A VGND VGND VPWR VPWR fanout96/X sky130_fd_sc_hd__clkdlybuf4s25_1
X_320_ _689_/Q _690_/Q _687_/Q _688_/Q VGND VGND VPWR VPWR _408_/C sky130_fd_sc_hd__and4_2
XFILLER_13_73 VGND VGND VPWR VPWR sky130_fd_sc_hd__fill_2
XFILLER_29_9 VGND VGND VPWR VPWR sky130_fd_sc_hd__decap_3
XTAP_TAPCELL_ROW_0_87 VGND VPWR sky130_fd_sc_hd__tapvpwrvgnd_1
XFILLER_38_81 VGND VGND VPWR VPWR sky130_fd_sc_hd__decap_3
X_518_ _660_/Q _661_/Q _521_/D _518_/B1 _421_/A VGND VGND VPWR VPWR _519_/B sky130_fd_sc_hd__a311o_2
Xclkload11 _703_/CLK VGND VGND VPWR VPWR clkload11/X sky130_fd_sc_hd__clkbuf_4
X_449_ _506_/A _507_/B VGND VGND VPWR VPWR _477_/A sky130_fd_sc_hd__and2_2
XFILLER_18_29 VGND VGND VPWR VPWR sky130_fd_sc_hd__decap_3
Xclkload5 _669_/CLK VGND VGND VPWR VPWR clkload5/X sky130_fd_sc_hd__clkbuf_4
XFILLER_40_60 VGND VGND VPWR VPWR sky130_fd_sc_hd__decap_3
XFILLER_1_21 VGND VGND VPWR VPWR sky130_fd_sc_hd__decap_3
XFILLER_1_54 VGND VGND VPWR VPWR sky130_fd_sc_hd__fill_2
XFILLER_37_148 VGND VGND VPWR VPWR sky130_fd_sc_hd__fill_1
XFILLER_28_137 VGND VGND VPWR VPWR sky130_fd_sc_hd__decap_3
XFILLER_19_126 VGND VGND VPWR VPWR sky130_fd_sc_hd__decap_3
XFILLER_19_159 VGND VGND VPWR VPWR sky130_fd_sc_hd__decap_3
XFILLER_19_94 VGND VGND VPWR VPWR sky130_fd_sc_hd__decap_3
XFILLER_27_181 VGND VGND VPWR VPWR sky130_fd_sc_hd__decap_3
XFILLER_35_60 VGND VGND VPWR VPWR sky130_fd_sc_hd__decap_3
XFILLER_34_129 VGND VGND VPWR VPWR sky130_fd_sc_hd__decap_3
XFILLER_18_192 VGND VGND VPWR VPWR sky130_fd_sc_hd__decap_3
XFILLER_33_162 VGND VGND VPWR VPWR sky130_fd_sc_hd__decap_3
XFILLER_31_18 VGND VGND VPWR VPWR sky130_fd_sc_hd__decap_3
XFILLER_0_228 VGND VGND VPWR VPWR sky130_fd_sc_hd__decap_3
XFILLER_24_195 VGND VGND VPWR VPWR sky130_fd_sc_hd__fill_1
XFILLER_21_40 VGND VGND VPWR VPWR sky130_fd_sc_hd__decap_3
XFILLER_21_95 VGND VGND VPWR VPWR sky130_fd_sc_hd__decap_3
X_697_ _712_/CLK _697_/D load_slew89/X VGND VGND VPWR VPWR _697_/Q sky130_fd_sc_hd__dfrtp_2
Xmax_cap71 _334_/Y VGND VGND VPWR VPWR _631_/D sky130_fd_sc_hd__clkbuf_2
XFILLER_15_184 VGND VGND VPWR VPWR sky130_fd_sc_hd__fill_1
XTAP_TAPCELL_ROW_17_157 VGND VPWR sky130_fd_sc_hd__tapvpwrvgnd_1
XFILLER_30_165 VGND VGND VPWR VPWR sky130_fd_sc_hd__decap_3
XFILLER_7_75 VGND VGND VPWR VPWR sky130_fd_sc_hd__fill_1
XFILLER_7_42 VGND VGND VPWR VPWR sky130_fd_sc_hd__decap_3
XFILLER_38_221 VGND VGND VPWR VPWR sky130_fd_sc_hd__decap_3
XFILLER_26_18 VGND VGND VPWR VPWR sky130_fd_sc_hd__decap_3
XPHY_EDGE_ROW_5_Right_5 VGND VGND VPWR VPWR sky130_fd_sc_hd__decap_3
XFILLER_21_154 VGND VGND VPWR VPWR sky130_fd_sc_hd__decap_3
XFILLER_21_187 VGND VGND VPWR VPWR sky130_fd_sc_hd__decap_3
X_551_ _574_/C _668_/Q _556_/A VGND VGND VPWR VPWR _551_/X sky130_fd_sc_hd__o21a_2
X_620_ _685_/Q _684_/Q _703_/Q VGND VGND VPWR VPWR _620_/X sky130_fd_sc_hd__and3_2
XFILLER_12_132 VGND VGND VPWR VPWR sky130_fd_sc_hd__decap_3
XFILLER_16_73 VGND VGND VPWR VPWR sky130_fd_sc_hd__decap_3
X_482_ _650_/Q _485_/C VGND VGND VPWR VPWR _483_/C sky130_fd_sc_hd__nand2_2
XTAP_TAPCELL_ROW_3_98 VGND VPWR sky130_fd_sc_hd__tapvpwrvgnd_1
XFILLER_8_147 VGND VGND VPWR VPWR sky130_fd_sc_hd__decap_3
Xhold114 _687_/Q VGND VGND VPWR VPWR _392_/B sky130_fd_sc_hd__dlygate4sd3_1
Xhold125 _703_/Q VGND VGND VPWR VPWR _619_/A1 sky130_fd_sc_hd__dlygate4sd3_1
Xhold136 _649_/Q VGND VGND VPWR VPWR _480_/A1 sky130_fd_sc_hd__dlygate4sd3_1
Xhold147 _657_/Q VGND VGND VPWR VPWR _502_/B1 sky130_fd_sc_hd__dlygate4sd3_1
XTAP_TAPCELL_ROW_5_106 VGND VPWR sky130_fd_sc_hd__tapvpwrvgnd_1
XFILLER_7_191 VGND VGND VPWR VPWR sky130_fd_sc_hd__decap_3
XTAP_TAPCELL_ROW_36_230 VGND VPWR sky130_fd_sc_hd__tapvpwrvgnd_1
XFILLER_5_128 VGND VGND VPWR VPWR sky130_fd_sc_hd__decap_3
XFILLER_27_50 VGND VGND VPWR VPWR sky130_fd_sc_hd__decap_3
X_534_ _665_/Q _664_/Q _666_/Q _534_/B1 VGND VGND VPWR VPWR _534_/X sky130_fd_sc_hd__a31o_2
X_603_ _603_/A _603_/B VGND VGND VPWR VPWR _603_/Y sky130_fd_sc_hd__nor2_2
X_465_ _465_/A _645_/Q _506_/A _506_/C VGND VGND VPWR VPWR _469_/C sky130_fd_sc_hd__and4_2
X_396_ _448_/A _396_/B _396_/C VGND VGND VPWR VPWR _689_/D sky130_fd_sc_hd__nor3_2
XFILLER_4_32 VGND VGND VPWR VPWR sky130_fd_sc_hd__decap_3
XFILLER_4_21 VGND VGND VPWR VPWR sky130_fd_sc_hd__decap_3
Xfanout86 fanout90/X VGND VGND VPWR VPWR fanout86/X sky130_fd_sc_hd__clkdlybuf4s25_1
XFILLER_1_131 VGND VGND VPWR VPWR sky130_fd_sc_hd__decap_3
XTAP_TAPCELL_ROW_0_88 VGND VPWR sky130_fd_sc_hd__tapvpwrvgnd_1
X_517_ _660_/Q _521_/D _517_/B1 VGND VGND VPWR VPWR _519_/A sky130_fd_sc_hd__a21oi_2
X_448_ _448_/A _465_/A _533_/A VGND VGND VPWR VPWR _507_/B sky130_fd_sc_hd__or3_2
Xclkload12 _675_/CLK VGND VGND VPWR VPWR clkload12/X sky130_fd_sc_hd__clkbuf_4
X_379_ _523_/B VGND VGND VPWR VPWR _622_/D sky130_fd_sc_hd__inv_2
XFILLER_34_18 VGND VGND VPWR VPWR sky130_fd_sc_hd__decap_3
Xclkload6 _670_/CLK VGND VGND VPWR VPWR clkload6/X sky130_fd_sc_hd__clkbuf_4
XFILLER_34_29 VGND VGND VPWR VPWR sky130_fd_sc_hd__fill_1
XFILLER_40_72 VGND VGND VPWR VPWR sky130_fd_sc_hd__decap_3
XFILLER_1_33 VGND VGND VPWR VPWR sky130_fd_sc_hd__decap_3
XFILLER_1_66 VGND VGND VPWR VPWR sky130_fd_sc_hd__fill_2
XFILLER_37_127 VGND VGND VPWR VPWR sky130_fd_sc_hd__fill_1
XFILLER_28_127 VGND VGND VPWR VPWR sky130_fd_sc_hd__fill_2
XFILLER_29_18 VGND VGND VPWR VPWR sky130_fd_sc_hd__decap_3
XPHY_EDGE_ROW_7_Left_48 VGND VGND VPWR VPWR sky130_fd_sc_hd__decap_3
XFILLER_10_42 VGND VGND VPWR VPWR sky130_fd_sc_hd__decap_3
XFILLER_10_97 VGND VGND VPWR VPWR sky130_fd_sc_hd__decap_3
XFILLER_34_108 VGND VGND VPWR VPWR sky130_fd_sc_hd__decap_3
XFILLER_35_94 VGND VGND VPWR VPWR sky130_fd_sc_hd__decap_3
XFILLER_35_83 VGND VGND VPWR VPWR sky130_fd_sc_hd__decap_3
XFILLER_18_3 VGND VGND VPWR VPWR sky130_fd_sc_hd__decap_3
XFILLER_33_141 VGND VGND VPWR VPWR sky130_fd_sc_hd__decap_3
XFILLER_33_196 VGND VGND VPWR VPWR sky130_fd_sc_hd__decap_3
XFILLER_21_52 VGND VGND VPWR VPWR sky130_fd_sc_hd__decap_3
XFILLER_21_63 VGND VGND VPWR VPWR sky130_fd_sc_hd__fill_2
XFILLER_15_152 VGND VGND VPWR VPWR sky130_fd_sc_hd__decap_3
X_696_ _712_/CLK _696_/D load_slew89/X VGND VGND VPWR VPWR _696_/Q sky130_fd_sc_hd__dfrtp_2
XFILLER_30_100 VGND VGND VPWR VPWR sky130_fd_sc_hd__decap_3
XFILLER_7_54 VGND VGND VPWR VPWR sky130_fd_sc_hd__fill_2
XFILLER_7_21 VGND VGND VPWR VPWR sky130_fd_sc_hd__decap_3
XFILLER_30_144 VGND VGND VPWR VPWR sky130_fd_sc_hd__decap_3
XFILLER_21_166 VGND VGND VPWR VPWR sky130_fd_sc_hd__fill_2
XFILLER_29_211 VGND VGND VPWR VPWR sky130_fd_sc_hd__decap_3
X_550_ _550_/A _550_/B VGND VGND VPWR VPWR _668_/D sky130_fd_sc_hd__xnor2_2
X_481_ _650_/Q _485_/C VGND VGND VPWR VPWR _483_/B sky130_fd_sc_hd__or2_2
XFILLER_12_144 VGND VGND VPWR VPWR sky130_fd_sc_hd__decap_3
XFILLER_16_85 VGND VGND VPWR VPWR sky130_fd_sc_hd__decap_3
XPHY_EDGE_ROW_11_Right_11 VGND VGND VPWR VPWR sky130_fd_sc_hd__decap_3
XFILLER_32_51 VGND VGND VPWR VPWR sky130_fd_sc_hd__decap_3
XTAP_TAPCELL_ROW_3_99 VGND VPWR sky130_fd_sc_hd__tapvpwrvgnd_1
XPHY_EDGE_ROW_20_Right_20 VGND VGND VPWR VPWR sky130_fd_sc_hd__decap_3
X_679_ _703_/CLK _679_/D fanout98/X VGND VGND VPWR VPWR _679_/Q sky130_fd_sc_hd__dfrtp_2
Xhold115 _690_/Q VGND VGND VPWR VPWR _398_/A1 sky130_fd_sc_hd__dlygate4sd3_1
Xhold126 _694_/Q VGND VGND VPWR VPWR _308_/A sky130_fd_sc_hd__dlygate4sd3_1
Xhold137 _679_/Q VGND VGND VPWR VPWR _596_/B1 sky130_fd_sc_hd__dlygate4sd3_1
Xhold148 _692_/Q VGND VGND VPWR VPWR _401_/B1 sky130_fd_sc_hd__dlygate4sd3_1
XTAP_TAPCELL_ROW_5_107 VGND VPWR sky130_fd_sc_hd__tapvpwrvgnd_1
XFILLER_26_236 VGND VGND VPWR VPWR sky130_fd_sc_hd__fill_1
XTAP_TAPCELL_ROW_36_231 VGND VPWR sky130_fd_sc_hd__tapvpwrvgnd_1
XFILLER_37_18 VGND VGND VPWR VPWR sky130_fd_sc_hd__decap_3
XPHY_EDGE_ROW_36_Left_77 VGND VGND VPWR VPWR sky130_fd_sc_hd__decap_3
XFILLER_17_203 VGND VGND VPWR VPWR sky130_fd_sc_hd__decap_3
X_602_ _614_/B _602_/B VGND VGND VPWR VPWR _680_/D sky130_fd_sc_hd__xnor2_2
XFILLER_17_214 VGND VGND VPWR VPWR sky130_fd_sc_hd__decap_3
XFILLER_17_225 VGND VGND VPWR VPWR sky130_fd_sc_hd__decap_3
X_533_ _533_/A _533_/B _533_/C VGND VGND VPWR VPWR _533_/X sky130_fd_sc_hd__and3_2
X_464_ _522_/A _464_/B _464_/C VGND VGND VPWR VPWR _644_/D sky130_fd_sc_hd__and3_2
XFILLER_32_206 VGND VGND VPWR VPWR sky130_fd_sc_hd__decap_3
X_395_ _687_/Q _688_/Q _395_/B1 VGND VGND VPWR VPWR _395_/Y sky130_fd_sc_hd__a21oi_2
XFILLER_4_99 VGND VGND VPWR VPWR sky130_fd_sc_hd__decap_3
XFILLER_4_88 VGND VGND VPWR VPWR sky130_fd_sc_hd__fill_2
XFILLER_4_44 VGND VGND VPWR VPWR sky130_fd_sc_hd__decap_3
XFILLER_4_195 VGND VGND VPWR VPWR sky130_fd_sc_hd__fill_1
Xfanout76 _574_/C VGND VGND VPWR VPWR _566_/A sky130_fd_sc_hd__clkdlybuf4s25_1
Xfanout98 fanout98/A VGND VGND VPWR VPWR fanout98/X sky130_fd_sc_hd__clkdlybuf4s25_1
XFILLER_1_143 VGND VGND VPWR VPWR sky130_fd_sc_hd__decap_3
XTAP_TAPCELL_ROW_0_89 VGND VPWR sky130_fd_sc_hd__tapvpwrvgnd_1
X_516_ _660_/Q _521_/D _513_/Y _515_/Y VGND VGND VPWR VPWR _660_/D sky130_fd_sc_hd__o22a_2
X_447_ _639_/Q _443_/X _640_/Q VGND VGND VPWR VPWR _450_/C sky130_fd_sc_hd__a21o_2
X_378_ _533_/A _527_/B _435_/B VGND VGND VPWR VPWR _523_/B sky130_fd_sc_hd__or3b_2
XFILLER_9_221 VGND VGND VPWR VPWR sky130_fd_sc_hd__decap_3
Xclkload13 _709_/CLK VGND VGND VPWR VPWR clkload13/X sky130_fd_sc_hd__clkbuf_4
Xclkload7 _711_/CLK VGND VGND VPWR VPWR clkload7/X sky130_fd_sc_hd__clkbuf_4
XFILLER_1_9 VGND VGND VPWR VPWR sky130_fd_sc_hd__decap_3
XFILLER_24_52 VGND VGND VPWR VPWR sky130_fd_sc_hd__decap_3
XFILLER_24_96 VGND VGND VPWR VPWR sky130_fd_sc_hd__decap_3
XFILLER_6_235 VGND VGND VPWR VPWR sky130_fd_sc_hd__fill_2
XFILLER_1_12 VGND VGND VPWR VPWR sky130_fd_sc_hd__decap_3
XPHY_EDGE_ROW_39_Left_80 VGND VGND VPWR VPWR sky130_fd_sc_hd__decap_3
XFILLER_34_9 VGND VGND VPWR VPWR sky130_fd_sc_hd__decap_3
XFILLER_1_45 VGND VGND VPWR VPWR sky130_fd_sc_hd__decap_3
XPHY_EDGE_ROW_23_Left_64 VGND VGND VPWR VPWR sky130_fd_sc_hd__decap_3
XFILLER_36_194 VGND VGND VPWR VPWR sky130_fd_sc_hd__fill_2
XFILLER_19_63 VGND VGND VPWR VPWR sky130_fd_sc_hd__decap_3
XFILLER_27_172 VGND VGND VPWR VPWR sky130_fd_sc_hd__decap_3
XFILLER_35_73 VGND VGND VPWR VPWR sky130_fd_sc_hd__decap_3
XFILLER_32_6 VGND VGND VPWR VPWR sky130_fd_sc_hd__decap_3
XFILLER_25_109 VGND VGND VPWR VPWR sky130_fd_sc_hd__decap_3
XFILLER_33_153 VGND VGND VPWR VPWR sky130_fd_sc_hd__decap_3
XFILLER_33_131 VGND VGND VPWR VPWR sky130_fd_sc_hd__decap_3
XFILLER_24_186 VGND VGND VPWR VPWR sky130_fd_sc_hd__decap_3
XFILLER_24_197 VGND VGND VPWR VPWR sky130_fd_sc_hd__decap_3
XFILLER_21_86 VGND VGND VPWR VPWR sky130_fd_sc_hd__decap_3
XFILLER_15_164 VGND VGND VPWR VPWR sky130_fd_sc_hd__decap_3
X_695_ _712_/CLK _695_/D fanout90/X VGND VGND VPWR VPWR _695_/Q sky130_fd_sc_hd__dfrtp_2
XFILLER_7_66 VGND VGND VPWR VPWR sky130_fd_sc_hd__decap_3
XFILLER_7_33 VGND VGND VPWR VPWR sky130_fd_sc_hd__decap_3
XFILLER_30_3 VGND VGND VPWR VPWR sky130_fd_sc_hd__decap_3
XFILLER_21_101 VGND VGND VPWR VPWR sky130_fd_sc_hd__fill_2
XPHY_EDGE_ROW_10_Left_51 VGND VGND VPWR VPWR sky130_fd_sc_hd__decap_3
XFILLER_16_64 VGND VGND VPWR VPWR sky130_fd_sc_hd__decap_3
X_480_ _480_/A1 _493_/C _479_/Y _522_/A VGND VGND VPWR VPWR _649_/D sky130_fd_sc_hd__o211a_2
XFILLER_8_116 VGND VGND VPWR VPWR sky130_fd_sc_hd__decap_3
XFILLER_32_85 VGND VGND VPWR VPWR sky130_fd_sc_hd__decap_3
X_678_ _709_/CLK _678_/D fanout98/X VGND VGND VPWR VPWR _678_/Q sky130_fd_sc_hd__dfrtp_2
XTAP_TAPCELL_ROW_13_140 VGND VPWR sky130_fd_sc_hd__tapvpwrvgnd_1
Xhold105 _712_/Q VGND VGND VPWR VPWR _706_/D sky130_fd_sc_hd__dlygate4sd3_1
Xhold116 _637_/Q VGND VGND VPWR VPWR _441_/A2 sky130_fd_sc_hd__dlygate4sd3_1
Xhold127 _410_/Y VGND VGND VPWR VPWR _694_/D sky130_fd_sc_hd__dlygate4sd3_1
Xhold138 _648_/Q VGND VGND VPWR VPWR _316_/A sky130_fd_sc_hd__dlygate4sd3_1
Xhold149 _682_/Q VGND VGND VPWR VPWR _612_/A1 sky130_fd_sc_hd__dlygate4sd3_1
XTAP_TAPCELL_ROW_5_108 VGND VPWR sky130_fd_sc_hd__tapvpwrvgnd_1
XTAP_TAPCELL_ROW_36_232 VGND VPWR sky130_fd_sc_hd__tapvpwrvgnd_1
XFILLER_5_119 VGND VGND VPWR VPWR sky130_fd_sc_hd__decap_3
XFILLER_5_108 VGND VGND VPWR VPWR sky130_fd_sc_hd__decap_3
X_601_ _604_/A _601_/A2 _599_/Y _600_/X VGND VGND VPWR VPWR _602_/B sky130_fd_sc_hd__a211o_2
X_532_ _665_/Q _531_/Y _532_/S VGND VGND VPWR VPWR _665_/D sky130_fd_sc_hd__mux2_1
X_463_ _477_/A _506_/C VGND VGND VPWR VPWR _464_/C sky130_fd_sc_hd__nand2_2
X_394_ _392_/B _394_/A2 _393_/Y VGND VGND VPWR VPWR _394_/X sky130_fd_sc_hd__o21a_2
XFILLER_4_56 VGND VGND VPWR VPWR sky130_fd_sc_hd__decap_3
XFILLER_4_152 VGND VGND VPWR VPWR sky130_fd_sc_hd__decap_3
XFILLER_4_12 VGND VGND VPWR VPWR sky130_fd_sc_hd__decap_3
XFILLER_23_207 VGND VGND VPWR VPWR sky130_fd_sc_hd__decap_3
XFILLER_14_218 VGND VGND VPWR VPWR sky130_fd_sc_hd__decap_3
XFILLER_13_21 VGND VGND VPWR VPWR sky130_fd_sc_hd__fill_1
XFILLER_13_43 VGND VGND VPWR VPWR sky130_fd_sc_hd__decap_3
XFILLER_13_87 VGND VGND VPWR VPWR sky130_fd_sc_hd__decap_3
XFILLER_13_98 VGND VGND VPWR VPWR sky130_fd_sc_hd__decap_3
Xfanout88 fanout90/X VGND VGND VPWR VPWR fanout88/X sky130_fd_sc_hd__clkdlybuf4s25_1
XFILLER_1_100 VGND VGND VPWR VPWR sky130_fd_sc_hd__decap_3
XFILLER_1_122 VGND VGND VPWR VPWR sky130_fd_sc_hd__decap_3
XFILLER_8_3 VGND VGND VPWR VPWR sky130_fd_sc_hd__decap_3
X_515_ _660_/Q _515_/B VGND VGND VPWR VPWR _515_/Y sky130_fd_sc_hd__nor2_2
X_446_ _446_/A1 _443_/X _445_/Y VGND VGND VPWR VPWR _639_/D sky130_fd_sc_hd__a21oi_2
X_377_ _372_/X _376_/X _369_/X VGND VGND VPWR VPWR _527_/B sky130_fd_sc_hd__a21oi_2
XFILLER_9_200 VGND VGND VPWR VPWR sky130_fd_sc_hd__decap_3
Xclkload14 _677_/CLK VGND VGND VPWR VPWR clkload14/X sky130_fd_sc_hd__clkbuf_4
Xclkload8 _708_/CLK VGND VGND VPWR VPWR clkload8/X sky130_fd_sc_hd__clkbuf_4
XFILLER_40_85 VGND VGND VPWR VPWR sky130_fd_sc_hd__decap_3
XFILLER_40_63 VGND VGND VPWR VPWR sky130_fd_sc_hd__decap_3
XFILLER_40_52 VGND VGND VPWR VPWR sky130_fd_sc_hd__decap_3
XFILLER_1_24 VGND VGND VPWR VPWR sky130_fd_sc_hd__decap_3
XFILLER_37_118 VGND VGND VPWR VPWR sky130_fd_sc_hd__decap_3
XFILLER_1_57 VGND VGND VPWR VPWR sky130_fd_sc_hd__decap_3
X_429_ _430_/A _420_/Y _430_/B _428_/X _407_/A VGND VGND VPWR VPWR _701_/D sky130_fd_sc_hd__o311a_2
Xinput1 en_i VGND VGND VPWR VPWR _465_/A sky130_fd_sc_hd__clkdlybuf4s25_1
XFILLER_19_129 VGND VGND VPWR VPWR sky130_fd_sc_hd__decap_3
XFILLER_19_42 VGND VGND VPWR VPWR sky130_fd_sc_hd__decap_3
XPHY_EDGE_ROW_40_Left_81 VGND VGND VPWR VPWR sky130_fd_sc_hd__decap_3
XFILLER_19_97 VGND VGND VPWR VPWR sky130_fd_sc_hd__decap_3
XFILLER_27_184 VGND VGND VPWR VPWR sky130_fd_sc_hd__decap_3
XFILLER_35_63 VGND VGND VPWR VPWR sky130_fd_sc_hd__decap_3
XFILLER_18_162 VGND VGND VPWR VPWR sky130_fd_sc_hd__fill_1
XFILLER_18_184 VGND VGND VPWR VPWR sky130_fd_sc_hd__fill_2
XFILLER_18_195 VGND VGND VPWR VPWR sky130_fd_sc_hd__fill_1
XFILLER_33_165 VGND VGND VPWR VPWR sky130_fd_sc_hd__decap_3
XFILLER_21_43 VGND VGND VPWR VPWR sky130_fd_sc_hd__decap_3
XFILLER_21_98 VGND VGND VPWR VPWR sky130_fd_sc_hd__decap_3
X_694_ _705_/CLK _694_/D fanout90/X VGND VGND VPWR VPWR _694_/Q sky130_fd_sc_hd__dfrtp_2
XFILLER_15_132 VGND VGND VPWR VPWR sky130_fd_sc_hd__decap_3
XFILLER_7_45 VGND VGND VPWR VPWR sky130_fd_sc_hd__decap_3
XFILLER_7_12 VGND VGND VPWR VPWR sky130_fd_sc_hd__decap_3
XFILLER_30_168 VGND VGND VPWR VPWR sky130_fd_sc_hd__decap_3
XFILLER_23_3 VGND VGND VPWR VPWR sky130_fd_sc_hd__fill_1
XFILLER_21_157 VGND VGND VPWR VPWR sky130_fd_sc_hd__fill_1
XFILLER_12_135 VGND VGND VPWR VPWR sky130_fd_sc_hd__decap_3
XFILLER_16_76 VGND VGND VPWR VPWR sky130_fd_sc_hd__fill_1
XFILLER_12_168 VGND VGND VPWR VPWR sky130_fd_sc_hd__fill_1
XFILLER_20_190 VGND VGND VPWR VPWR sky130_fd_sc_hd__decap_3
XTAP_TAPCELL_ROW_22_174 VGND VPWR sky130_fd_sc_hd__tapvpwrvgnd_1
X_677_ _677_/CLK _677_/D fanout98/A VGND VGND VPWR VPWR _677_/Q sky130_fd_sc_hd__dfrtp_2
XTAP_TAPCELL_ROW_13_141 VGND VPWR sky130_fd_sc_hd__tapvpwrvgnd_1
XFILLER_11_190 VGND VGND VPWR VPWR sky130_fd_sc_hd__decap_3
Xhold106 _711_/Q VGND VGND VPWR VPWR _705_/D sky130_fd_sc_hd__dlygate4sd3_1
Xhold117 _691_/Q VGND VGND VPWR VPWR _400_/A1 sky130_fd_sc_hd__dlygate4sd3_1
Xhold128 _698_/Q VGND VGND VPWR VPWR _422_/A1 sky130_fd_sc_hd__dlygate4sd3_1
Xhold139 _661_/Q VGND VGND VPWR VPWR _517_/B1 sky130_fd_sc_hd__dlygate4sd3_1
XPHY_EDGE_ROW_9_Right_9 VGND VGND VPWR VPWR sky130_fd_sc_hd__decap_3
XFILLER_7_194 VGND VGND VPWR VPWR sky130_fd_sc_hd__decap_3
XFILLER_7_172 VGND VGND VPWR VPWR sky130_fd_sc_hd__decap_3
XTAP_TAPCELL_ROW_5_109 VGND VPWR sky130_fd_sc_hd__tapvpwrvgnd_1
XTAP_TAPCELL_ROW_36_233 VGND VPWR sky130_fd_sc_hd__tapvpwrvgnd_1
XFILLER_27_53 VGND VGND VPWR VPWR sky130_fd_sc_hd__decap_3
X_531_ _435_/X _530_/Y _529_/X VGND VGND VPWR VPWR _531_/Y sky130_fd_sc_hd__o21ai_2
X_600_ _611_/A1 _605_/A1 _604_/A _603_/B VGND VGND VPWR VPWR _600_/X sky130_fd_sc_hd__o211a_2
X_462_ _642_/Q _641_/Q _644_/Q _643_/Q VGND VGND VPWR VPWR _506_/C sky130_fd_sc_hd__and4_2
X_393_ _687_/Q _688_/Q _448_/A VGND VGND VPWR VPWR _393_/Y sky130_fd_sc_hd__a21oi_2
XFILLER_4_24 VGND VGND VPWR VPWR sky130_fd_sc_hd__decap_3
XFILLER_4_35 VGND VGND VPWR VPWR sky130_fd_sc_hd__decap_3
XFILLER_22_241 VGND VGND VPWR VPWR sky130_fd_sc_hd__decap_3
Xfanout78 _542_/A1 VGND VGND VPWR VPWR _574_/C sky130_fd_sc_hd__clkdlybuf4s25_1
XFILLER_1_134 VGND VGND VPWR VPWR sky130_fd_sc_hd__decap_3
X_514_ _317_/Y _511_/C _513_/Y VGND VGND VPWR VPWR _514_/Y sky130_fd_sc_hd__a21boi_2
XFILLER_38_85 VGND VGND VPWR VPWR sky130_fd_sc_hd__decap_3
X_445_ _446_/A1 _443_/X _458_/A VGND VGND VPWR VPWR _445_/Y sky130_fd_sc_hd__o21ai_2
X_376_ _704_/Q _614_/A _376_/C VGND VGND VPWR VPWR _376_/X sky130_fd_sc_hd__and3_2
XTAP_TAPCELL_ROW_30_206 VGND VPWR sky130_fd_sc_hd__tapvpwrvgnd_1
Xclkload9 _705_/CLK VGND VGND VPWR VPWR clkload9/X sky130_fd_sc_hd__clkbuf_4
XFILLER_10_200 VGND VGND VPWR VPWR sky130_fd_sc_hd__decap_3
XFILLER_24_32 VGND VGND VPWR VPWR sky130_fd_sc_hd__fill_1
XFILLER_24_65 VGND VGND VPWR VPWR sky130_fd_sc_hd__fill_1
XFILLER_6_204 VGND VGND VPWR VPWR sky130_fd_sc_hd__fill_2
XFILLER_40_75 VGND VGND VPWR VPWR sky130_fd_sc_hd__decap_3
XFILLER_1_36 VGND VGND VPWR VPWR sky130_fd_sc_hd__decap_3
X_428_ _700_/Q _699_/Q _421_/B _701_/Q VGND VGND VPWR VPWR _428_/X sky130_fd_sc_hd__a31o_2
X_359_ _364_/A _359_/B VGND VGND VPWR VPWR _625_/D sky130_fd_sc_hd__nor2_2
XTAP_TAPCELL_ROW_1_90 VGND VPWR sky130_fd_sc_hd__tapvpwrvgnd_1
Xinput2 fast_mode_i VGND VGND VPWR VPWR input2/X sky130_fd_sc_hd__clkdlybuf4s25_1
XFILLER_36_152 VGND VGND VPWR VPWR sky130_fd_sc_hd__decap_3
XFILLER_10_12 VGND VGND VPWR VPWR sky130_fd_sc_hd__fill_2
XFILLER_10_45 VGND VGND VPWR VPWR sky130_fd_sc_hd__decap_3
XFILLER_27_152 VGND VGND VPWR VPWR sky130_fd_sc_hd__decap_3
XFILLER_35_97 VGND VGND VPWR VPWR sky130_fd_sc_hd__fill_2
XFILLER_18_6 VGND VGND VPWR VPWR sky130_fd_sc_hd__fill_1
XFILLER_33_111 VGND VGND VPWR VPWR sky130_fd_sc_hd__fill_1
XFILLER_33_199 VGND VGND VPWR VPWR sky130_fd_sc_hd__decap_3
XFILLER_33_144 VGND VGND VPWR VPWR sky130_fd_sc_hd__decap_3
XFILLER_33_122 VGND VGND VPWR VPWR sky130_fd_sc_hd__decap_3
XFILLER_21_55 VGND VGND VPWR VPWR sky130_fd_sc_hd__fill_1
X_693_ _705_/CLK _693_/D fanout90/X VGND VGND VPWR VPWR _693_/Q sky130_fd_sc_hd__dfrtp_2
XFILLER_15_111 VGND VGND VPWR VPWR sky130_fd_sc_hd__fill_1
XFILLER_15_155 VGND VGND VPWR VPWR sky130_fd_sc_hd__decap_3
XFILLER_30_103 VGND VGND VPWR VPWR sky130_fd_sc_hd__decap_3
XFILLER_30_147 VGND VGND VPWR VPWR sky130_fd_sc_hd__decap_3
XFILLER_7_57 VGND VGND VPWR VPWR sky130_fd_sc_hd__decap_3
XFILLER_7_24 VGND VGND VPWR VPWR sky130_fd_sc_hd__decap_3
XTAP_TAPCELL_ROW_16_150 VGND VPWR sky130_fd_sc_hd__tapvpwrvgnd_1
XTAP_TAPCELL_ROW_8_118 VGND VPWR sky130_fd_sc_hd__tapvpwrvgnd_1
XFILLER_29_214 VGND VGND VPWR VPWR sky130_fd_sc_hd__fill_2
XFILLER_29_225 VGND VGND VPWR VPWR sky130_fd_sc_hd__decap_3
XTAP_TAPCELL_ROW_39_242 VGND VPWR sky130_fd_sc_hd__tapvpwrvgnd_1
XFILLER_16_88 VGND VGND VPWR VPWR sky130_fd_sc_hd__decap_3
XFILLER_16_99 VGND VGND VPWR VPWR sky130_fd_sc_hd__decap_3
XFILLER_32_21 VGND VGND VPWR VPWR sky130_fd_sc_hd__decap_3
XTAP_TAPCELL_ROW_22_175 VGND VPWR sky130_fd_sc_hd__tapvpwrvgnd_1
XFILLER_32_54 VGND VGND VPWR VPWR sky130_fd_sc_hd__decap_3
X_676_ _677_/CLK _676_/D fanout98/X VGND VGND VPWR VPWR _676_/Q sky130_fd_sc_hd__dfrtp_2
XFILLER_35_239 VGND VGND VPWR VPWR sky130_fd_sc_hd__decap_3
XFILLER_7_140 VGND VGND VPWR VPWR sky130_fd_sc_hd__fill_2
Xhold107 _713_/Q VGND VGND VPWR VPWR _707_/D sky130_fd_sc_hd__dlygate4sd3_1
Xhold118 _646_/Q VGND VGND VPWR VPWR _468_/A1 sky130_fd_sc_hd__dlygate4sd3_1
Xhold129 _659_/Q VGND VGND VPWR VPWR _317_/A sky130_fd_sc_hd__dlygate4sd3_1
XFILLER_17_206 VGND VGND VPWR VPWR sky130_fd_sc_hd__decap_3
XFILLER_17_217 VGND VGND VPWR VPWR sky130_fd_sc_hd__decap_3
XFILLER_17_228 VGND VGND VPWR VPWR sky130_fd_sc_hd__fill_1
XFILLER_27_87 VGND VGND VPWR VPWR sky130_fd_sc_hd__decap_3
X_530_ _665_/Q _664_/Q VGND VGND VPWR VPWR _530_/Y sky130_fd_sc_hd__xnor2_2
X_461_ _506_/A _457_/A _507_/B _644_/Q VGND VGND VPWR VPWR _464_/B sky130_fd_sc_hd__a31o_2
XFILLER_32_209 VGND VGND VPWR VPWR sky130_fd_sc_hd__decap_3
X_392_ _448_/A _392_/B VGND VGND VPWR VPWR _687_/D sky130_fd_sc_hd__nor2_2
XFILLER_40_231 VGND VGND VPWR VPWR sky130_fd_sc_hd__decap_3
XFILLER_40_220 VGND VGND VPWR VPWR sky130_fd_sc_hd__decap_3
XFILLER_4_47 VGND VGND VPWR VPWR sky130_fd_sc_hd__decap_3
X_659_ _669_/CLK _659_/D fanout95/X VGND VGND VPWR VPWR _659_/Q sky130_fd_sc_hd__dfrtp_2
Xfanout79 _542_/A1 VGND VGND VPWR VPWR _518_/B1 sky130_fd_sc_hd__clkdlybuf4s25_1
XFILLER_13_67 VGND VGND VPWR VPWR sky130_fd_sc_hd__decap_3
XFILLER_1_113 VGND VGND VPWR VPWR sky130_fd_sc_hd__decap_3
XFILLER_1_146 VGND VGND VPWR VPWR sky130_fd_sc_hd__fill_1
XFILLER_38_53 VGND VGND VPWR VPWR sky130_fd_sc_hd__decap_3
XFILLER_38_20 VGND VGND VPWR VPWR sky130_fd_sc_hd__decap_3
X_513_ _507_/B _515_/B _521_/D VGND VGND VPWR VPWR _513_/Y sky130_fd_sc_hd__a21oi_2
X_444_ _443_/X _458_/A _444_/C VGND VGND VPWR VPWR _638_/D sky130_fd_sc_hd__and3b_2
X_375_ _614_/A _376_/C VGND VGND VPWR VPWR _593_/A sky130_fd_sc_hd__and2_2
XTAP_TAPCELL_ROW_30_207 VGND VPWR sky130_fd_sc_hd__tapvpwrvgnd_1
XFILLER_5_90 VGND VGND VPWR VPWR sky130_fd_sc_hd__decap_3
XFILLER_10_212 VGND VGND VPWR VPWR sky130_fd_sc_hd__decap_3
XFILLER_24_55 VGND VGND VPWR VPWR sky130_fd_sc_hd__decap_3
XFILLER_24_99 VGND VGND VPWR VPWR sky130_fd_sc_hd__decap_3
XFILLER_40_32 VGND VGND VPWR VPWR sky130_fd_sc_hd__decap_3
XFILLER_40_21 VGND VGND VPWR VPWR sky130_fd_sc_hd__decap_3
XFILLER_1_15 VGND VGND VPWR VPWR sky130_fd_sc_hd__decap_3
XFILLER_1_48 VGND VGND VPWR VPWR sky130_fd_sc_hd__decap_3
X_427_ _427_/A1 _699_/Q _421_/B _425_/Y _448_/A VGND VGND VPWR VPWR _427_/Y sky130_fd_sc_hd__a311oi_2
X_358_ _351_/X _362_/A _362_/B VGND VGND VPWR VPWR _359_/B sky130_fd_sc_hd__and3b_2
XTAP_TAPCELL_ROW_1_91 VGND VPWR sky130_fd_sc_hd__tapvpwrvgnd_1
XPHY_EDGE_ROW_18_Right_18 VGND VGND VPWR VPWR sky130_fd_sc_hd__decap_3
Xinput3 inc_hour_i VGND VGND VPWR VPWR _713_/D sky130_fd_sc_hd__clkdlybuf4s25_1
XPHY_EDGE_ROW_27_Right_27 VGND VGND VPWR VPWR sky130_fd_sc_hd__decap_3
XFILLER_36_197 VGND VGND VPWR VPWR sky130_fd_sc_hd__decap_3
XFILLER_36_131 VGND VGND VPWR VPWR sky130_fd_sc_hd__decap_3
XFILLER_10_79 VGND VGND VPWR VPWR sky130_fd_sc_hd__decap_3
XPHY_EDGE_ROW_36_Right_36 VGND VGND VPWR VPWR sky130_fd_sc_hd__decap_3
XFILLER_19_66 VGND VGND VPWR VPWR sky130_fd_sc_hd__decap_3
XFILLER_27_164 VGND VGND VPWR VPWR sky130_fd_sc_hd__decap_3
XFILLER_27_175 VGND VGND VPWR VPWR sky130_fd_sc_hd__decap_3
XFILLER_35_54 VGND VGND VPWR VPWR sky130_fd_sc_hd__fill_2
XFILLER_35_21 VGND VGND VPWR VPWR sky130_fd_sc_hd__decap_3
XPHY_EDGE_ROW_27_Left_68 VGND VGND VPWR VPWR sky130_fd_sc_hd__decap_3
XFILLER_32_9 VGND VGND VPWR VPWR sky130_fd_sc_hd__decap_3
XFILLER_18_197 VGND VGND VPWR VPWR sky130_fd_sc_hd__decap_3
XFILLER_33_156 VGND VGND VPWR VPWR sky130_fd_sc_hd__decap_3
XFILLER_2_91 VGND VGND VPWR VPWR sky130_fd_sc_hd__fill_1
XFILLER_24_156 VGND VGND VPWR VPWR sky130_fd_sc_hd__decap_3
XFILLER_24_189 VGND VGND VPWR VPWR sky130_fd_sc_hd__decap_3
XFILLER_21_89 VGND VGND VPWR VPWR sky130_fd_sc_hd__decap_3
XFILLER_15_123 VGND VGND VPWR VPWR sky130_fd_sc_hd__decap_3
X_692_ _705_/CLK _692_/D load_slew87/X VGND VGND VPWR VPWR _692_/Q sky130_fd_sc_hd__dfrtp_2
XFILLER_15_167 VGND VGND VPWR VPWR sky130_fd_sc_hd__fill_1
XFILLER_30_137 VGND VGND VPWR VPWR sky130_fd_sc_hd__decap_3
XFILLER_7_36 VGND VGND VPWR VPWR sky130_fd_sc_hd__decap_3
XFILLER_7_69 VGND VGND VPWR VPWR sky130_fd_sc_hd__decap_3
XFILLER_30_6 VGND VGND VPWR VPWR sky130_fd_sc_hd__decap_3
XTAP_TAPCELL_ROW_16_151 VGND VPWR sky130_fd_sc_hd__tapvpwrvgnd_1
XTAP_TAPCELL_ROW_8_119 VGND VPWR sky130_fd_sc_hd__tapvpwrvgnd_1
XTAP_TAPCELL_ROW_39_243 VGND VPWR sky130_fd_sc_hd__tapvpwrvgnd_1
XFILLER_12_126 VGND VGND VPWR VPWR sky130_fd_sc_hd__decap_3
XFILLER_16_67 VGND VGND VPWR VPWR sky130_fd_sc_hd__decap_3
XTAP_TAPCELL_ROW_22_176 VGND VPWR sky130_fd_sc_hd__tapvpwrvgnd_1
XPHY_EDGE_ROW_0_Right_0 VGND VGND VPWR VPWR sky130_fd_sc_hd__decap_3
XFILLER_32_88 VGND VGND VPWR VPWR sky130_fd_sc_hd__decap_3
X_675_ _675_/CLK _675_/D fanout98/A VGND VGND VPWR VPWR _675_/Q sky130_fd_sc_hd__dfrtp_2
XFILLER_35_218 VGND VGND VPWR VPWR sky130_fd_sc_hd__fill_1
XFILLER_11_181 VGND VGND VPWR VPWR sky130_fd_sc_hd__decap_3
Xhold108 _705_/Q VGND VGND VPWR VPWR _708_/D sky130_fd_sc_hd__dlygate4sd3_1
XFILLER_7_163 VGND VGND VPWR VPWR sky130_fd_sc_hd__decap_3
Xhold119 _678_/Q VGND VGND VPWR VPWR _591_/B1 sky130_fd_sc_hd__dlygate4sd3_1
XFILLER_7_185 VGND VGND VPWR VPWR sky130_fd_sc_hd__decap_3
XPHY_EDGE_ROW_14_Left_55 VGND VGND VPWR VPWR sky130_fd_sc_hd__decap_3
XFILLER_34_240 VGND VGND VPWR VPWR sky130_fd_sc_hd__decap_3
X_460_ _507_/B _515_/B VGND VGND VPWR VPWR _522_/A sky130_fd_sc_hd__nand2_2
X_391_ _465_/A _552_/A _391_/C VGND VGND VPWR VPWR _704_/D sky130_fd_sc_hd__and3_2
XFILLER_4_59 VGND VGND VPWR VPWR sky130_fd_sc_hd__decap_3
XFILLER_4_177 VGND VGND VPWR VPWR sky130_fd_sc_hd__decap_3
XFILLER_4_155 VGND VGND VPWR VPWR sky130_fd_sc_hd__fill_1
XFILLER_4_15 VGND VGND VPWR VPWR sky130_fd_sc_hd__decap_3
XFILLER_4_111 VGND VGND VPWR VPWR sky130_fd_sc_hd__decap_3
X_589_ _593_/A _587_/X _588_/X _318_/Y _585_/A VGND VGND VPWR VPWR _589_/X sky130_fd_sc_hd__o221a_2
X_658_ _669_/CLK _658_/D fanout95/X VGND VGND VPWR VPWR _658_/Q sky130_fd_sc_hd__dfrtp_2
XFILLER_13_46 VGND VGND VPWR VPWR sky130_fd_sc_hd__decap_3
XFILLER_13_57 VGND VGND VPWR VPWR sky130_fd_sc_hd__fill_2
XFILLER_1_103 VGND VGND VPWR VPWR sky130_fd_sc_hd__decap_3
XFILLER_1_125 VGND VGND VPWR VPWR sky130_fd_sc_hd__decap_3
XFILLER_8_6 VGND VGND VPWR VPWR sky130_fd_sc_hd__decap_3
X_512_ _658_/Q _659_/Q _512_/C _512_/D VGND VGND VPWR VPWR _521_/D sky130_fd_sc_hd__and4_2
X_443_ _465_/A _637_/Q _638_/Q VGND VGND VPWR VPWR _443_/X sky130_fd_sc_hd__and3_2
X_374_ _677_/Q _679_/Q _678_/Q _676_/Q VGND VGND VPWR VPWR _376_/C sky130_fd_sc_hd__and4bb_2
XTAP_TAPCELL_ROW_30_208 VGND VPWR sky130_fd_sc_hd__tapvpwrvgnd_1
XFILLER_9_225 VGND VGND VPWR VPWR sky130_fd_sc_hd__decap_3
XFILLER_9_203 VGND VGND VPWR VPWR sky130_fd_sc_hd__fill_2
XFILLER_40_66 VGND VGND VPWR VPWR sky130_fd_sc_hd__decap_3
XFILLER_40_55 VGND VGND VPWR VPWR sky130_fd_sc_hd__fill_1
XFILLER_6_3 VGND VGND VPWR VPWR sky130_fd_sc_hd__decap_3
XFILLER_1_27 VGND VGND VPWR VPWR sky130_fd_sc_hd__decap_3
X_426_ _700_/Q _699_/Q VGND VGND VPWR VPWR _430_/B sky130_fd_sc_hd__nand2_2
X_357_ _353_/B _356_/Y _354_/Y VGND VGND VPWR VPWR _624_/D sky130_fd_sc_hd__a21oi_2
Xinput4 inc_min_i VGND VGND VPWR VPWR _712_/D sky130_fd_sc_hd__clkdlybuf4s25_1
XTAP_TAPCELL_ROW_1_92 VGND VPWR sky130_fd_sc_hd__tapvpwrvgnd_1
XFILLER_36_165 VGND VGND VPWR VPWR sky130_fd_sc_hd__fill_1
XFILLER_19_12 VGND VGND VPWR VPWR sky130_fd_sc_hd__decap_3
XFILLER_19_45 VGND VGND VPWR VPWR sky130_fd_sc_hd__decap_3
XFILLER_27_143 VGND VGND VPWR VPWR sky130_fd_sc_hd__decap_3
XFILLER_27_187 VGND VGND VPWR VPWR sky130_fd_sc_hd__fill_2
XFILLER_35_66 VGND VGND VPWR VPWR sky130_fd_sc_hd__fill_1
XPHY_EDGE_ROW_2_Left_43 VGND VGND VPWR VPWR sky130_fd_sc_hd__decap_3
XFILLER_33_113 VGND VGND VPWR VPWR sky130_fd_sc_hd__decap_3
X_409_ _421_/A _419_/D VGND VGND VPWR VPWR _409_/Y sky130_fd_sc_hd__nor2_2
XFILLER_24_102 VGND VGND VPWR VPWR sky130_fd_sc_hd__fill_1
XFILLER_24_124 VGND VGND VPWR VPWR sky130_fd_sc_hd__decap_3
XFILLER_21_46 VGND VGND VPWR VPWR sky130_fd_sc_hd__decap_3
XFILLER_21_57 VGND VGND VPWR VPWR sky130_fd_sc_hd__decap_3
XFILLER_15_102 VGND VGND VPWR VPWR sky130_fd_sc_hd__decap_3
XFILLER_15_135 VGND VGND VPWR VPWR sky130_fd_sc_hd__decap_3
X_691_ _705_/CLK _691_/D load_slew87/X VGND VGND VPWR VPWR _691_/Q sky130_fd_sc_hd__dfrtp_2
XFILLER_7_48 VGND VGND VPWR VPWR sky130_fd_sc_hd__decap_3
XFILLER_7_15 VGND VGND VPWR VPWR sky130_fd_sc_hd__decap_3
XTAP_TAPCELL_ROW_16_152 VGND VPWR sky130_fd_sc_hd__tapvpwrvgnd_1
XTAP_TAPCELL_ROW_39_244 VGND VPWR sky130_fd_sc_hd__tapvpwrvgnd_1
XFILLER_12_116 VGND VGND VPWR VPWR sky130_fd_sc_hd__fill_2
XFILLER_12_138 VGND VGND VPWR VPWR sky130_fd_sc_hd__fill_2
XFILLER_20_193 VGND VGND VPWR VPWR sky130_fd_sc_hd__decap_3
XTAP_TAPCELL_ROW_22_177 VGND VPWR sky130_fd_sc_hd__tapvpwrvgnd_1
XFILLER_32_12 VGND VGND VPWR VPWR sky130_fd_sc_hd__decap_3
X_674_ _677_/CLK _674_/D _630_/SET_B VGND VGND VPWR VPWR _674_/Q sky130_fd_sc_hd__dfrtp_2
Xhold109 _706_/Q VGND VGND VPWR VPWR _709_/D sky130_fd_sc_hd__dlygate4sd3_1
XFILLER_7_175 VGND VGND VPWR VPWR sky130_fd_sc_hd__fill_2
XFILLER_7_131 VGND VGND VPWR VPWR sky130_fd_sc_hd__decap_3
XFILLER_21_3 VGND VGND VPWR VPWR sky130_fd_sc_hd__fill_2
X_390_ _384_/X _389_/X _448_/A VGND VGND VPWR VPWR _391_/C sky130_fd_sc_hd__a21o_2
XFILLER_40_211 VGND VGND VPWR VPWR sky130_fd_sc_hd__decap_3
XPHY_EDGE_ROW_31_Left_72 VGND VGND VPWR VPWR sky130_fd_sc_hd__decap_3
XFILLER_4_38 VGND VGND VPWR VPWR sky130_fd_sc_hd__decap_3
XFILLER_4_27 VGND VGND VPWR VPWR sky130_fd_sc_hd__fill_1
X_657_ _669_/CLK _657_/D load_slew92/X VGND VGND VPWR VPWR _657_/Q sky130_fd_sc_hd__dfrtp_2
X_588_ _603_/A _588_/B _588_/C VGND VGND VPWR VPWR _588_/X sky130_fd_sc_hd__or3_2
XFILLER_22_244 VGND VGND VPWR VPWR sky130_fd_sc_hd__fill_1
XFILLER_1_137 VGND VGND VPWR VPWR sky130_fd_sc_hd__decap_3
XFILLER_38_11 VGND VGND VPWR VPWR sky130_fd_sc_hd__decap_3
X_511_ _522_/A _511_/B _511_/C VGND VGND VPWR VPWR _658_/D sky130_fd_sc_hd__and3_2
X_442_ _465_/A _637_/Q _638_/Q VGND VGND VPWR VPWR _444_/C sky130_fd_sc_hd__a21o_2
X_373_ _681_/Q _682_/Q _683_/Q _680_/Q VGND VGND VPWR VPWR _614_/A sky130_fd_sc_hd__and4bb_2
XTAP_TAPCELL_ROW_30_209 VGND VPWR sky130_fd_sc_hd__tapvpwrvgnd_1
X_709_ _709_/CLK _709_/D fanout98/X VGND VGND VPWR VPWR _709_/Q sky130_fd_sc_hd__dfrtp_2
XFILLER_10_203 VGND VGND VPWR VPWR sky130_fd_sc_hd__decap_3
XFILLER_40_78 VGND VGND VPWR VPWR sky130_fd_sc_hd__decap_3
XFILLER_40_12 VGND VGND VPWR VPWR sky130_fd_sc_hd__decap_3
XFILLER_1_39 VGND VGND VPWR VPWR sky130_fd_sc_hd__decap_3
X_425_ _699_/Q _421_/B _700_/Q VGND VGND VPWR VPWR _425_/Y sky130_fd_sc_hd__a21oi_2
X_356_ _362_/A _351_/X _342_/B VGND VGND VPWR VPWR _356_/Y sky130_fd_sc_hd__a21oi_2
XTAP_TAPCELL_ROW_1_93 VGND VPWR sky130_fd_sc_hd__tapvpwrvgnd_1
Xinput5 inc_sec_i VGND VGND VPWR VPWR _711_/D sky130_fd_sc_hd__clkdlybuf4s25_1
XFILLER_36_100 VGND VGND VPWR VPWR sky130_fd_sc_hd__fill_2
XFILLER_36_188 VGND VGND VPWR VPWR sky130_fd_sc_hd__decap_3
XFILLER_36_177 VGND VGND VPWR VPWR sky130_fd_sc_hd__decap_3
XFILLER_36_155 VGND VGND VPWR VPWR sky130_fd_sc_hd__fill_2
XFILLER_19_57 VGND VGND VPWR VPWR sky130_fd_sc_hd__decap_3
XFILLER_27_111 VGND VGND VPWR VPWR sky130_fd_sc_hd__fill_1
XFILLER_27_155 VGND VGND VPWR VPWR sky130_fd_sc_hd__decap_3
XFILLER_35_12 VGND VGND VPWR VPWR sky130_fd_sc_hd__decap_3
X_408_ _694_/Q _693_/Q _408_/C _408_/D VGND VGND VPWR VPWR _419_/D sky130_fd_sc_hd__and4_2
XFILLER_33_147 VGND VGND VPWR VPWR sky130_fd_sc_hd__decap_3
XFILLER_33_125 VGND VGND VPWR VPWR sky130_fd_sc_hd__decap_3
X_339_ _666_/Q _634_/D VGND VGND VPWR VPWR _341_/B sky130_fd_sc_hd__and2_2
XFILLER_32_191 VGND VGND VPWR VPWR sky130_fd_sc_hd__decap_3
X_690_ _711_/CLK _690_/D load_slew87/X VGND VGND VPWR VPWR _690_/Q sky130_fd_sc_hd__dfrtp_2
XFILLER_15_158 VGND VGND VPWR VPWR sky130_fd_sc_hd__decap_3
XFILLER_15_169 VGND VGND VPWR VPWR sky130_fd_sc_hd__decap_3
XFILLER_30_106 VGND VGND VPWR VPWR sky130_fd_sc_hd__decap_3
XFILLER_30_117 VGND VGND VPWR VPWR sky130_fd_sc_hd__decap_3
XFILLER_23_191 VGND VGND VPWR VPWR sky130_fd_sc_hd__fill_1
XTAP_TAPCELL_ROW_25_186 VGND VPWR sky130_fd_sc_hd__tapvpwrvgnd_1
XFILLER_7_27 VGND VGND VPWR VPWR sky130_fd_sc_hd__decap_3
Xclkbuf_4_9_0_clk clkbuf_0_clk/X VGND VGND VPWR VPWR _708_/CLK sky130_fd_sc_hd__clkbuf_8
XFILLER_14_191 VGND VGND VPWR VPWR sky130_fd_sc_hd__decap_3
XTAP_TAPCELL_ROW_16_153 VGND VPWR sky130_fd_sc_hd__tapvpwrvgnd_1
Xinput30 load_sec_tens_i[3] VGND VGND VPWR VPWR _588_/C sky130_fd_sc_hd__clkdlybuf4s25_1
XFILLER_29_228 VGND VGND VPWR VPWR sky130_fd_sc_hd__fill_1
XFILLER_16_47 VGND VGND VPWR VPWR sky130_fd_sc_hd__decap_3
XTAP_TAPCELL_ROW_39_245 VGND VPWR sky130_fd_sc_hd__tapvpwrvgnd_1
XFILLER_20_150 VGND VGND VPWR VPWR sky130_fd_sc_hd__decap_3
XFILLER_32_57 VGND VGND VPWR VPWR sky130_fd_sc_hd__decap_3
XFILLER_32_24 VGND VGND VPWR VPWR sky130_fd_sc_hd__decap_3
X_673_ _677_/CLK _673_/D _630_/SET_B VGND VGND VPWR VPWR _673_/Q sky130_fd_sc_hd__dfrtp_2
XFILLER_11_172 VGND VGND VPWR VPWR sky130_fd_sc_hd__decap_3
XFILLER_14_3 VGND VGND VPWR VPWR sky130_fd_sc_hd__decap_3
XFILLER_27_24 VGND VGND VPWR VPWR sky130_fd_sc_hd__decap_3
XFILLER_27_57 VGND VGND VPWR VPWR sky130_fd_sc_hd__fill_1
XTAP_TAPCELL_ROW_4_102 VGND VPWR sky130_fd_sc_hd__tapvpwrvgnd_1
XFILLER_40_234 VGND VGND VPWR VPWR sky130_fd_sc_hd__decap_3
XFILLER_40_223 VGND VGND VPWR VPWR sky130_fd_sc_hd__fill_1
XTAP_TAPCELL_ROW_10_126 VGND VPWR sky130_fd_sc_hd__tapvpwrvgnd_1
XFILLER_4_102 VGND VGND VPWR VPWR sky130_fd_sc_hd__decap_3
X_587_ _677_/Q _676_/Q _564_/A VGND VGND VPWR VPWR _587_/X sky130_fd_sc_hd__a21o_2
X_656_ _667_/CLK _656_/D load_slew92/X VGND VGND VPWR VPWR _656_/Q sky130_fd_sc_hd__dfrtp_2
XTAP_TAPCELL_ROW_33_218 VGND VPWR sky130_fd_sc_hd__tapvpwrvgnd_1
XFILLER_1_116 VGND VGND VPWR VPWR sky130_fd_sc_hd__decap_3
XFILLER_38_23 VGND VGND VPWR VPWR sky130_fd_sc_hd__decap_3
X_510_ _658_/Q _510_/B VGND VGND VPWR VPWR _511_/C sky130_fd_sc_hd__nand2_2
X_441_ _465_/A _441_/A2 _440_/Y VGND VGND VPWR VPWR _637_/D sky130_fd_sc_hd__a21oi_2
XFILLER_38_78 VGND VGND VPWR VPWR sky130_fd_sc_hd__decap_3
XFILLER_38_56 VGND VGND VPWR VPWR sky130_fd_sc_hd__fill_1
XFILLER_13_212 VGND VGND VPWR VPWR sky130_fd_sc_hd__decap_3
X_372_ _668_/Q _670_/Q _545_/B _372_/D VGND VGND VPWR VPWR _372_/X sky130_fd_sc_hd__and4_2
XFILLER_0_193 VGND VGND VPWR VPWR sky130_fd_sc_hd__decap_3
X_639_ _642_/CLK _639_/D load_slew83/X VGND VGND VPWR VPWR _639_/Q sky130_fd_sc_hd__dfrtp_2
X_708_ _708_/CLK _708_/D load_slew89/X VGND VGND VPWR VPWR _708_/Q sky130_fd_sc_hd__dfrtp_2
XFILLER_5_93 VGND VGND VPWR VPWR sky130_fd_sc_hd__decap_3
XFILLER_5_60 VGND VGND VPWR VPWR sky130_fd_sc_hd__decap_3
XFILLER_10_215 VGND VGND VPWR VPWR sky130_fd_sc_hd__decap_3
XFILLER_24_25 VGND VGND VPWR VPWR sky130_fd_sc_hd__decap_3
XFILLER_40_57 VGND VGND VPWR VPWR sky130_fd_sc_hd__decap_3
XFILLER_40_46 VGND VGND VPWR VPWR sky130_fd_sc_hd__decap_3
XFILLER_40_35 VGND VGND VPWR VPWR sky130_fd_sc_hd__decap_3
XFILLER_40_24 VGND VGND VPWR VPWR sky130_fd_sc_hd__decap_3
XFILLER_1_18 VGND VGND VPWR VPWR sky130_fd_sc_hd__decap_3
X_424_ _699_/Q _421_/B _423_/Y VGND VGND VPWR VPWR _699_/D sky130_fd_sc_hd__o21a_2
X_355_ _362_/A _351_/X _362_/B VGND VGND VPWR VPWR _355_/X sky130_fd_sc_hd__a21o_2
Xinput6 load_en_i VGND VGND VPWR VPWR input6/X sky130_fd_sc_hd__clkdlybuf4s25_1
XFILLER_19_69 VGND VGND VPWR VPWR sky130_fd_sc_hd__fill_1
XFILLER_27_167 VGND VGND VPWR VPWR sky130_fd_sc_hd__fill_1
XFILLER_27_178 VGND VGND VPWR VPWR sky130_fd_sc_hd__decap_3
XFILLER_35_57 VGND VGND VPWR VPWR sky130_fd_sc_hd__decap_3
XFILLER_35_24 VGND VGND VPWR VPWR sky130_fd_sc_hd__decap_3
XPHY_EDGE_ROW_14_Right_14 VGND VGND VPWR VPWR sky130_fd_sc_hd__decap_3
XFILLER_2_200 VGND VGND VPWR VPWR sky130_fd_sc_hd__decap_3
XPHY_EDGE_ROW_23_Right_23 VGND VGND VPWR VPWR sky130_fd_sc_hd__decap_3
XFILLER_18_112 VGND VGND VPWR VPWR sky130_fd_sc_hd__decap_3
XFILLER_18_123 VGND VGND VPWR VPWR sky130_fd_sc_hd__decap_3
X_407_ _407_/A _407_/B _407_/C VGND VGND VPWR VPWR _693_/D sky130_fd_sc_hd__and3_2
X_338_ _682_/Q _328_/Y _631_/D _678_/Q VGND VGND VPWR VPWR _341_/A sky130_fd_sc_hd__a22o_2
XPHY_EDGE_ROW_32_Right_32 VGND VGND VPWR VPWR sky130_fd_sc_hd__decap_3
XFILLER_33_159 VGND VGND VPWR VPWR sky130_fd_sc_hd__decap_3
XFILLER_2_50 VGND VGND VPWR VPWR sky130_fd_sc_hd__decap_3
XFILLER_24_159 VGND VGND VPWR VPWR sky130_fd_sc_hd__decap_3
XTAP_TAPCELL_ROW_19_162 VGND VPWR sky130_fd_sc_hd__tapvpwrvgnd_1
XFILLER_32_170 VGND VGND VPWR VPWR sky130_fd_sc_hd__decap_3
XFILLER_15_126 VGND VGND VPWR VPWR sky130_fd_sc_hd__decap_3
XTAP_TAPCELL_ROW_25_187 VGND VPWR sky130_fd_sc_hd__tapvpwrvgnd_1
XFILLER_7_39 VGND VGND VPWR VPWR sky130_fd_sc_hd__decap_3
XFILLER_11_70 VGND VGND VPWR VPWR sky130_fd_sc_hd__decap_3
XFILLER_11_92 VGND VGND VPWR VPWR sky130_fd_sc_hd__decap_3
XFILLER_38_218 VGND VGND VPWR VPWR sky130_fd_sc_hd__decap_3
XFILLER_30_9 VGND VGND VPWR VPWR sky130_fd_sc_hd__decap_3
Xinput31 rst_n VGND VGND VPWR VPWR input31/X sky130_fd_sc_hd__clkdlybuf4s25_1
Xinput20 load_min_tens_i[1] VGND VGND VPWR VPWR _548_/A2 sky130_fd_sc_hd__clkdlybuf4s25_1
XFILLER_12_129 VGND VGND VPWR VPWR sky130_fd_sc_hd__decap_3
XFILLER_16_37 VGND VGND VPWR VPWR sky130_fd_sc_hd__fill_2
XFILLER_20_162 VGND VGND VPWR VPWR sky130_fd_sc_hd__fill_1
XFILLER_20_184 VGND VGND VPWR VPWR sky130_fd_sc_hd__decap_3
X_672_ _677_/CLK _672_/D _630_/SET_B VGND VGND VPWR VPWR _672_/Q sky130_fd_sc_hd__dfrtp_2
XFILLER_7_122 VGND VGND VPWR VPWR sky130_fd_sc_hd__decap_3
XFILLER_11_184 VGND VGND VPWR VPWR sky130_fd_sc_hd__decap_3
XFILLER_22_91 VGND VGND VPWR VPWR sky130_fd_sc_hd__fill_1
XFILLER_7_188 VGND VGND VPWR VPWR sky130_fd_sc_hd__decap_3
XFILLER_7_166 VGND VGND VPWR VPWR sky130_fd_sc_hd__fill_2
XFILLER_34_243 VGND VGND VPWR VPWR sky130_fd_sc_hd__fill_2
XFILLER_8_71 VGND VGND VPWR VPWR sky130_fd_sc_hd__fill_2
XTAP_TAPCELL_ROW_4_103 VGND VPWR sky130_fd_sc_hd__tapvpwrvgnd_1
XPHY_EDGE_ROW_4_Right_4 VGND VGND VPWR VPWR sky130_fd_sc_hd__decap_3
XFILLER_25_210 VGND VGND VPWR VPWR sky130_fd_sc_hd__decap_3
Xclkbuf_4_8_0_clk clkbuf_0_clk/X VGND VGND VPWR VPWR _711_/CLK sky130_fd_sc_hd__clkbuf_8
XTAP_TAPCELL_ROW_10_127 VGND VPWR sky130_fd_sc_hd__tapvpwrvgnd_1
XFILLER_4_29 VGND VGND VPWR VPWR sky130_fd_sc_hd__decap_3
XFILLER_4_18 VGND VGND VPWR VPWR sky130_fd_sc_hd__decap_3
XFILLER_4_114 VGND VGND VPWR VPWR sky130_fd_sc_hd__decap_3
X_586_ _564_/A _676_/Q _585_/A VGND VGND VPWR VPWR _586_/X sky130_fd_sc_hd__o21a_2
X_655_ _713_/CLK _655_/D load_slew92/X VGND VGND VPWR VPWR _655_/Q sky130_fd_sc_hd__dfrtp_2
XTAP_TAPCELL_ROW_33_219 VGND VPWR sky130_fd_sc_hd__tapvpwrvgnd_1
XPHY_EDGE_ROW_18_Left_59 VGND VGND VPWR VPWR sky130_fd_sc_hd__decap_3
XFILLER_3_180 VGND VGND VPWR VPWR sky130_fd_sc_hd__fill_1
XFILLER_1_106 VGND VGND VPWR VPWR sky130_fd_sc_hd__decap_3
XFILLER_1_128 VGND VGND VPWR VPWR sky130_fd_sc_hd__decap_3
XFILLER_8_9 VGND VGND VPWR VPWR sky130_fd_sc_hd__decap_3
X_440_ _465_/A _441_/A2 _458_/A VGND VGND VPWR VPWR _440_/Y sky130_fd_sc_hd__o21ai_2
X_371_ _669_/Q _671_/Q VGND VGND VPWR VPWR _372_/D sky130_fd_sc_hd__nor2_2
XFILLER_9_228 VGND VGND VPWR VPWR sky130_fd_sc_hd__fill_1
XFILLER_0_161 VGND VGND VPWR VPWR sky130_fd_sc_hd__decap_3
X_707_ _713_/CLK _707_/D load_slew92/X VGND VGND VPWR VPWR _707_/Q sky130_fd_sc_hd__dfrtp_2
X_569_ _564_/B _569_/B _574_/C VGND VGND VPWR VPWR _569_/X sky130_fd_sc_hd__and3b_2
X_638_ _642_/CLK _638_/D load_slew83/X VGND VGND VPWR VPWR _638_/Q sky130_fd_sc_hd__dfrtp_2
XFILLER_24_15 VGND VGND VPWR VPWR sky130_fd_sc_hd__fill_2
XFILLER_39_198 VGND VGND VPWR VPWR sky130_fd_sc_hd__decap_3
XFILLER_6_6 VGND VGND VPWR VPWR sky130_fd_sc_hd__decap_3
XFILLER_40_69 VGND VGND VPWR VPWR sky130_fd_sc_hd__decap_3
X_423_ _699_/Q _421_/B _448_/A VGND VGND VPWR VPWR _423_/Y sky130_fd_sc_hd__a21oi_2
X_354_ _342_/A _342_/B _346_/X VGND VGND VPWR VPWR _354_/Y sky130_fd_sc_hd__a21boi_2
XFILLER_39_6 VGND VGND VPWR VPWR sky130_fd_sc_hd__decap_3
XFILLER_30_91 VGND VGND VPWR VPWR sky130_fd_sc_hd__decap_3
Xinput7 load_hour_ones_i[0] VGND VGND VPWR VPWR input7/X sky130_fd_sc_hd__clkdlybuf4s25_1
XFILLER_10_39 VGND VGND VPWR VPWR sky130_fd_sc_hd__decap_3
XFILLER_19_15 VGND VGND VPWR VPWR sky130_fd_sc_hd__decap_3
XFILLER_19_48 VGND VGND VPWR VPWR sky130_fd_sc_hd__fill_1
XFILLER_27_113 VGND VGND VPWR VPWR sky130_fd_sc_hd__fill_2
XFILLER_27_146 VGND VGND VPWR VPWR sky130_fd_sc_hd__decap_3
XFILLER_4_3 VGND VGND VPWR VPWR sky130_fd_sc_hd__decap_3
XFILLER_18_146 VGND VGND VPWR VPWR sky130_fd_sc_hd__decap_3
XFILLER_33_116 VGND VGND VPWR VPWR sky130_fd_sc_hd__decap_3
XFILLER_25_91 VGND VGND VPWR VPWR sky130_fd_sc_hd__decap_3
X_406_ _693_/Q _406_/B VGND VGND VPWR VPWR _407_/C sky130_fd_sc_hd__nand2_2
X_337_ _337_/A _337_/B _332_/Y VGND VGND VPWR VPWR _362_/A sky130_fd_sc_hd__or3b_2
XFILLER_2_62 VGND VGND VPWR VPWR sky130_fd_sc_hd__fill_2
XFILLER_37_3 VGND VGND VPWR VPWR sky130_fd_sc_hd__decap_3
XFILLER_24_127 VGND VGND VPWR VPWR sky130_fd_sc_hd__fill_2
XTAP_TAPCELL_ROW_19_163 VGND VPWR sky130_fd_sc_hd__tapvpwrvgnd_1
XFILLER_21_49 VGND VGND VPWR VPWR sky130_fd_sc_hd__decap_3
XFILLER_32_182 VGND VGND VPWR VPWR sky130_fd_sc_hd__decap_3
XFILLER_15_105 VGND VGND VPWR VPWR sky130_fd_sc_hd__decap_3
Xmax_cap69 _354_/Y VGND VGND VPWR VPWR _364_/A sky130_fd_sc_hd__buf_2
XPHY_EDGE_ROW_6_Left_47 VGND VGND VPWR VPWR sky130_fd_sc_hd__decap_3
XFILLER_15_138 VGND VGND VPWR VPWR sky130_fd_sc_hd__decap_3
XFILLER_23_160 VGND VGND VPWR VPWR sky130_fd_sc_hd__decap_3
XFILLER_23_182 VGND VGND VPWR VPWR sky130_fd_sc_hd__decap_3
XTAP_TAPCELL_ROW_25_188 VGND VPWR sky130_fd_sc_hd__tapvpwrvgnd_1
XFILLER_7_18 VGND VGND VPWR VPWR sky130_fd_sc_hd__decap_3
Xinput21 load_min_tens_i[2] VGND VGND VPWR VPWR _552_/B sky130_fd_sc_hd__clkdlybuf4s25_1
Xinput10 load_hour_ones_i[3] VGND VGND VPWR VPWR _529_/C sky130_fd_sc_hd__clkdlybuf4s25_1
XFILLER_20_141 VGND VGND VPWR VPWR sky130_fd_sc_hd__decap_3
XFILLER_32_15 VGND VGND VPWR VPWR sky130_fd_sc_hd__decap_3
X_671_ _675_/CLK _671_/D _630_/SET_B VGND VGND VPWR VPWR _671_/Q sky130_fd_sc_hd__dfrtp_2
XFILLER_7_134 VGND VGND VPWR VPWR sky130_fd_sc_hd__decap_3
XTAP_TAPCELL_ROW_4_104 VGND VPWR sky130_fd_sc_hd__tapvpwrvgnd_1
XFILLER_25_222 VGND VGND VPWR VPWR sky130_fd_sc_hd__fill_2
XTAP_TAPCELL_ROW_10_128 VGND VPWR sky130_fd_sc_hd__tapvpwrvgnd_1
XFILLER_40_225 VGND VGND VPWR VPWR sky130_fd_sc_hd__decap_3
XFILLER_40_214 VGND VGND VPWR VPWR sky130_fd_sc_hd__decap_3
X_654_ _713_/CLK _654_/D load_slew85/X VGND VGND VPWR VPWR _654_/Q sky130_fd_sc_hd__dfrtp_2
XFILLER_16_200 VGND VGND VPWR VPWR sky130_fd_sc_hd__fill_2
X_585_ _585_/A _585_/B VGND VGND VPWR VPWR _676_/D sky130_fd_sc_hd__xor2_2
XPHY_EDGE_ROW_9_Left_50 VGND VGND VPWR VPWR sky130_fd_sc_hd__decap_3
XFILLER_31_225 VGND VGND VPWR VPWR sky130_fd_sc_hd__decap_3
XFILLER_38_14 VGND VGND VPWR VPWR sky130_fd_sc_hd__decap_3
XFILLER_13_203 VGND VGND VPWR VPWR sky130_fd_sc_hd__decap_3
XFILLER_13_225 VGND VGND VPWR VPWR sky130_fd_sc_hd__decap_3
X_370_ _673_/Q _674_/Q _675_/Q _672_/Q VGND VGND VPWR VPWR _545_/B sky130_fd_sc_hd__and4bb_2
XPHY_EDGE_ROW_35_Left_76 VGND VGND VPWR VPWR sky130_fd_sc_hd__decap_3
XFILLER_9_218 VGND VGND VPWR VPWR sky130_fd_sc_hd__decap_3
XFILLER_28_91 VGND VGND VPWR VPWR sky130_fd_sc_hd__decap_3
X_637_ _642_/CLK _637_/D load_slew83/X VGND VGND VPWR VPWR _637_/Q sky130_fd_sc_hd__dfrtp_2
X_706_ _709_/CLK _706_/D fanout90/X VGND VGND VPWR VPWR _706_/Q sky130_fd_sc_hd__dfrtp_2
X_568_ _573_/S _568_/B VGND VGND VPWR VPWR _672_/D sky130_fd_sc_hd__xnor2_2
X_499_ _498_/X _499_/B _499_/C VGND VGND VPWR VPWR _655_/D sky130_fd_sc_hd__and3b_2
XFILLER_5_51 VGND VGND VPWR VPWR sky130_fd_sc_hd__decap_3
Xclkbuf_4_7_0_clk clkbuf_0_clk/X VGND VGND VPWR VPWR _670_/CLK sky130_fd_sc_hd__clkbuf_8
XFILLER_10_206 VGND VGND VPWR VPWR sky130_fd_sc_hd__decap_3
XFILLER_40_15 VGND VGND VPWR VPWR sky130_fd_sc_hd__decap_3
X_422_ _422_/A1 _420_/B _421_/Y VGND VGND VPWR VPWR _698_/D sky130_fd_sc_hd__o21a_2
X_353_ _353_/A _353_/B VGND VGND VPWR VPWR _623_/D sky130_fd_sc_hd__xnor2_2
XFILLER_30_70 VGND VGND VPWR VPWR sky130_fd_sc_hd__decap_3
Xinput8 load_hour_ones_i[1] VGND VGND VPWR VPWR input8/X sky130_fd_sc_hd__clkdlybuf4s25_1
XFILLER_10_29 VGND VGND VPWR VPWR sky130_fd_sc_hd__fill_2
XFILLER_27_158 VGND VGND VPWR VPWR sky130_fd_sc_hd__fill_2
XFILLER_35_15 VGND VGND VPWR VPWR sky130_fd_sc_hd__decap_3
XFILLER_27_169 VGND VGND VPWR VPWR sky130_fd_sc_hd__decap_3
XFILLER_33_128 VGND VGND VPWR VPWR sky130_fd_sc_hd__decap_3
XFILLER_25_70 VGND VGND VPWR VPWR sky130_fd_sc_hd__fill_1
X_405_ _693_/Q _406_/B VGND VGND VPWR VPWR _407_/B sky130_fd_sc_hd__or2_2
X_336_ _337_/A _337_/B _332_/Y VGND VGND VPWR VPWR _342_/A sky130_fd_sc_hd__nor3b_2
XFILLER_2_41 VGND VGND VPWR VPWR sky130_fd_sc_hd__decap_3
XFILLER_2_85 VGND VGND VPWR VPWR sky130_fd_sc_hd__decap_3
XPHY_EDGE_ROW_22_Left_63 VGND VGND VPWR VPWR sky130_fd_sc_hd__decap_3
XTAP_TAPCELL_ROW_19_164 VGND VPWR sky130_fd_sc_hd__tapvpwrvgnd_1
XFILLER_32_194 VGND VGND VPWR VPWR sky130_fd_sc_hd__fill_2
XFILLER_30_109 VGND VGND VPWR VPWR sky130_fd_sc_hd__fill_1
XTAP_TAPCELL_ROW_25_189 VGND VPWR sky130_fd_sc_hd__tapvpwrvgnd_1
XFILLER_14_150 VGND VGND VPWR VPWR sky130_fd_sc_hd__decap_3
XFILLER_36_91 VGND VGND VPWR VPWR sky130_fd_sc_hd__decap_3
XFILLER_36_80 VGND VGND VPWR VPWR sky130_fd_sc_hd__decap_3
XFILLER_14_194 VGND VGND VPWR VPWR sky130_fd_sc_hd__fill_2
Xinput22 load_min_tens_i[3] VGND VGND VPWR VPWR _552_/C sky130_fd_sc_hd__clkdlybuf4s25_1
Xinput11 load_hour_tens_i[0] VGND VGND VPWR VPWR _437_/D sky130_fd_sc_hd__clkdlybuf4s25_1
X_319_ _689_/Q _687_/Q _688_/Q VGND VGND VPWR VPWR _396_/B sky130_fd_sc_hd__and3_2
XFILLER_20_131 VGND VGND VPWR VPWR sky130_fd_sc_hd__decap_3
XFILLER_20_153 VGND VGND VPWR VPWR sky130_fd_sc_hd__decap_3
XFILLER_32_27 VGND VGND VPWR VPWR sky130_fd_sc_hd__fill_1
XFILLER_20_197 VGND VGND VPWR VPWR sky130_fd_sc_hd__fill_2
X_670_ _670_/CLK _670_/D fanout96/X VGND VGND VPWR VPWR _670_/Q sky130_fd_sc_hd__dfrtp_2
XFILLER_11_131 VGND VGND VPWR VPWR sky130_fd_sc_hd__fill_1
XFILLER_11_175 VGND VGND VPWR VPWR sky130_fd_sc_hd__decap_3
XTAP_TAPCELL_ROW_21_170 VGND VPWR sky130_fd_sc_hd__tapvpwrvgnd_1
XFILLER_7_113 VGND VGND VPWR VPWR sky130_fd_sc_hd__decap_3
XFILLER_14_6 VGND VGND VPWR VPWR sky130_fd_sc_hd__decap_3
XFILLER_27_27 VGND VGND VPWR VPWR sky130_fd_sc_hd__fill_2
XTAP_TAPCELL_ROW_4_105 VGND VPWR sky130_fd_sc_hd__tapvpwrvgnd_1
XTAP_TAPCELL_ROW_10_129 VGND VPWR sky130_fd_sc_hd__tapvpwrvgnd_1
XFILLER_4_105 VGND VGND VPWR VPWR sky130_fd_sc_hd__decap_3
XFILLER_4_149 VGND VGND VPWR VPWR sky130_fd_sc_hd__decap_3
X_653_ _653_/CLK _653_/D load_slew85/X VGND VGND VPWR VPWR _653_/Q sky130_fd_sc_hd__dfrtp_2
X_584_ _583_/X input27/X _676_/Q _603_/A VGND VGND VPWR VPWR _585_/B sky130_fd_sc_hd__a2bb2o_2
XFILLER_13_18 VGND VGND VPWR VPWR sky130_fd_sc_hd__decap_3
XFILLER_1_119 VGND VGND VPWR VPWR sky130_fd_sc_hd__decap_3
XFILLER_38_26 VGND VGND VPWR VPWR sky130_fd_sc_hd__fill_2
XFILLER_13_215 VGND VGND VPWR VPWR sky130_fd_sc_hd__fill_2
XFILLER_0_141 VGND VGND VPWR VPWR sky130_fd_sc_hd__decap_3
X_567_ _574_/C _567_/A2 _565_/X _566_/Y VGND VGND VPWR VPWR _568_/B sky130_fd_sc_hd__a211o_2
X_636_ _667_/CLK _636_/D load_slew92/X VGND VGND VPWR VPWR _636_/Q sky130_fd_sc_hd__dfrtp_2
X_705_ _705_/CLK _705_/D load_slew87/X VGND VGND VPWR VPWR _705_/Q sky130_fd_sc_hd__dfrtp_2
X_498_ _654_/Q _655_/Q _512_/C _498_/D VGND VGND VPWR VPWR _498_/X sky130_fd_sc_hd__and4_2
XFILLER_5_96 VGND VGND VPWR VPWR sky130_fd_sc_hd__decap_3
XFILLER_5_63 VGND VGND VPWR VPWR sky130_fd_sc_hd__decap_3
XFILLER_5_30 VGND VGND VPWR VPWR sky130_fd_sc_hd__decap_3
XFILLER_39_145 VGND VGND VPWR VPWR sky130_fd_sc_hd__fill_1
XFILLER_10_218 VGND VGND VPWR VPWR sky130_fd_sc_hd__fill_1
XFILLER_40_49 VGND VGND VPWR VPWR sky130_fd_sc_hd__decap_3
XFILLER_40_27 VGND VGND VPWR VPWR sky130_fd_sc_hd__fill_1
X_421_ _421_/A _421_/B VGND VGND VPWR VPWR _421_/Y sky130_fd_sc_hd__nor2_2
X_352_ _362_/A _351_/X _346_/X VGND VGND VPWR VPWR _353_/B sky130_fd_sc_hd__o21ba_2
XFILLER_30_82 VGND VGND VPWR VPWR sky130_fd_sc_hd__fill_2
Xinput9 load_hour_ones_i[2] VGND VGND VPWR VPWR _533_/B sky130_fd_sc_hd__clkdlybuf4s25_1
X_619_ _619_/A1 _334_/Y _618_/A _685_/Q VGND VGND VPWR VPWR _685_/D sky130_fd_sc_hd__a22o_2
XFILLER_18_126 VGND VGND VPWR VPWR sky130_fd_sc_hd__decap_3
XFILLER_18_159 VGND VGND VPWR VPWR sky130_fd_sc_hd__decap_3
XFILLER_25_60 VGND VGND VPWR VPWR sky130_fd_sc_hd__decap_3
XFILLER_26_192 VGND VGND VPWR VPWR sky130_fd_sc_hd__decap_3
X_404_ _421_/A _404_/B _406_/B VGND VGND VPWR VPWR _692_/D sky130_fd_sc_hd__nor3_2
XTAP_TAPCELL_ROW_28_198 VGND VPWR sky130_fd_sc_hd__tapvpwrvgnd_1
Xclkbuf_4_6_0_clk clkbuf_0_clk/X VGND VGND VPWR VPWR _669_/CLK sky130_fd_sc_hd__clkbuf_8
X_335_ _673_/Q _333_/Y _631_/D _677_/Q VGND VGND VPWR VPWR _337_/B sky130_fd_sc_hd__a22o_2
XFILLER_2_53 VGND VGND VPWR VPWR sky130_fd_sc_hd__decap_3
XPHY_EDGE_ROW_10_Right_10 VGND VGND VPWR VPWR sky130_fd_sc_hd__decap_3
XFILLER_17_181 VGND VGND VPWR VPWR sky130_fd_sc_hd__decap_3
XTAP_TAPCELL_ROW_19_165 VGND VPWR sky130_fd_sc_hd__tapvpwrvgnd_1
XFILLER_32_173 VGND VGND VPWR VPWR sky130_fd_sc_hd__decap_3
XFILLER_15_129 VGND VGND VPWR VPWR sky130_fd_sc_hd__decap_3
XFILLER_11_51 VGND VGND VPWR VPWR sky130_fd_sc_hd__decap_3
XFILLER_11_73 VGND VGND VPWR VPWR sky130_fd_sc_hd__decap_3
XFILLER_11_95 VGND VGND VPWR VPWR sky130_fd_sc_hd__decap_3
Xinput23 load_sec_ones_i[0] VGND VGND VPWR VPWR _601_/A2 sky130_fd_sc_hd__clkdlybuf4s25_1
Xinput12 load_hour_tens_i[1] VGND VGND VPWR VPWR _437_/C sky130_fd_sc_hd__clkdlybuf4s25_1
X_318_ _318_/A VGND VGND VPWR VPWR _318_/Y sky130_fd_sc_hd__inv_2
XFILLER_16_18 VGND VGND VPWR VPWR sky130_fd_sc_hd__decap_3
XFILLER_37_221 VGND VGND VPWR VPWR sky130_fd_sc_hd__decap_3
XFILLER_20_187 VGND VGND VPWR VPWR sky130_fd_sc_hd__decap_3
XTAP_TAPCELL_ROW_7_114 VGND VPWR sky130_fd_sc_hd__tapvpwrvgnd_1
XFILLER_28_210 VGND VGND VPWR VPWR sky130_fd_sc_hd__decap_3
XFILLER_11_110 VGND VGND VPWR VPWR sky130_fd_sc_hd__fill_2
XTAP_TAPCELL_ROW_13_138 VGND VPWR sky130_fd_sc_hd__tapvpwrvgnd_1
XFILLER_11_187 VGND VGND VPWR VPWR sky130_fd_sc_hd__decap_3
XFILLER_22_50 VGND VGND VPWR VPWR sky130_fd_sc_hd__fill_2
XTAP_TAPCELL_ROW_21_171 VGND VPWR sky130_fd_sc_hd__tapvpwrvgnd_1
XFILLER_7_169 VGND VGND VPWR VPWR sky130_fd_sc_hd__decap_3
XFILLER_7_125 VGND VGND VPWR VPWR sky130_fd_sc_hd__decap_3
XFILLER_19_210 VGND VGND VPWR VPWR sky130_fd_sc_hd__decap_3
XFILLER_8_41 VGND VGND VPWR VPWR sky130_fd_sc_hd__decap_3
XFILLER_25_213 VGND VGND VPWR VPWR sky130_fd_sc_hd__decap_3
XFILLER_40_205 VGND VGND VPWR VPWR sky130_fd_sc_hd__decap_3
XFILLER_4_117 VGND VGND VPWR VPWR sky130_fd_sc_hd__fill_2
X_583_ _588_/B _318_/A _588_/C _552_/A VGND VGND VPWR VPWR _583_/X sky130_fd_sc_hd__a211o_2
X_652_ _713_/CLK _652_/D fanout84/X VGND VGND VPWR VPWR _652_/Q sky130_fd_sc_hd__dfrtp_2
XFILLER_33_60 VGND VGND VPWR VPWR sky130_fd_sc_hd__fill_2
XPHY_EDGE_ROW_8_Right_8 VGND VGND VPWR VPWR sky130_fd_sc_hd__decap_3
XFILLER_1_109 VGND VGND VPWR VPWR sky130_fd_sc_hd__decap_3
XPHY_EDGE_ROW_39_Right_39 VGND VGND VPWR VPWR sky130_fd_sc_hd__decap_3
XFILLER_0_131 VGND VGND VPWR VPWR sky130_fd_sc_hd__decap_3
XFILLER_0_164 VGND VGND VPWR VPWR sky130_fd_sc_hd__fill_1
XFILLER_0_197 VGND VGND VPWR VPWR sky130_fd_sc_hd__fill_1
X_704_ _708_/CLK _704_/D fanout88/X VGND VGND VPWR VPWR _704_/Q sky130_fd_sc_hd__dfrtp_2
X_566_ _566_/A _672_/Q VGND VGND VPWR VPWR _566_/Y sky130_fd_sc_hd__nor2_2
X_635_ _669_/CLK _635_/D load_slew92/X VGND VGND VPWR VPWR _635_/Q sky130_fd_sc_hd__dfrtp_2
X_497_ _654_/Q _512_/C _498_/D _655_/Q VGND VGND VPWR VPWR _499_/C sky130_fd_sc_hd__a31o_2
XFILLER_5_42 VGND VGND VPWR VPWR sky130_fd_sc_hd__decap_3
XFILLER_39_113 VGND VGND VPWR VPWR sky130_fd_sc_hd__decap_3
XFILLER_24_29 VGND VGND VPWR VPWR sky130_fd_sc_hd__decap_3
XFILLER_6_9 VGND VGND VPWR VPWR sky130_fd_sc_hd__decap_3
X_420_ _698_/Q _420_/B VGND VGND VPWR VPWR _420_/Y sky130_fd_sc_hd__nand2_2
X_351_ _664_/Q _634_/D _349_/X _350_/X VGND VGND VPWR VPWR _351_/X sky130_fd_sc_hd__a211o_2
XFILLER_5_212 VGND VGND VPWR VPWR sky130_fd_sc_hd__decap_3
XFILLER_39_9 VGND VGND VPWR VPWR sky130_fd_sc_hd__decap_3
XFILLER_30_94 VGND VGND VPWR VPWR sky130_fd_sc_hd__decap_3
XFILLER_30_61 VGND VGND VPWR VPWR sky130_fd_sc_hd__decap_3
X_549_ _548_/X input19/X _668_/Q _552_/A VGND VGND VPWR VPWR _550_/B sky130_fd_sc_hd__a2bb2o_2
X_618_ _618_/A _618_/B VGND VGND VPWR VPWR _684_/D sky130_fd_sc_hd__and2_2
XFILLER_19_18 VGND VGND VPWR VPWR sky130_fd_sc_hd__decap_3
XFILLER_27_149 VGND VGND VPWR VPWR sky130_fd_sc_hd__decap_3
XFILLER_4_6 VGND VGND VPWR VPWR sky130_fd_sc_hd__decap_3
XFILLER_18_149 VGND VGND VPWR VPWR sky130_fd_sc_hd__fill_2
XFILLER_25_50 VGND VGND VPWR VPWR sky130_fd_sc_hd__decap_3
XFILLER_25_94 VGND VGND VPWR VPWR sky130_fd_sc_hd__decap_3
X_403_ _408_/C _408_/D VGND VGND VPWR VPWR _406_/B sky130_fd_sc_hd__and2_2
X_334_ _686_/Q _685_/Q _684_/Q VGND VGND VPWR VPWR _334_/Y sky130_fd_sc_hd__nor3b_2
XTAP_TAPCELL_ROW_28_199 VGND VPWR sky130_fd_sc_hd__tapvpwrvgnd_1
XFILLER_33_119 VGND VGND VPWR VPWR sky130_fd_sc_hd__decap_3
XFILLER_33_108 VGND VGND VPWR VPWR sky130_fd_sc_hd__decap_3
XFILLER_2_21 VGND VGND VPWR VPWR sky130_fd_sc_hd__decap_3
XFILLER_2_32 VGND VGND VPWR VPWR sky130_fd_sc_hd__decap_3
XFILLER_37_6 VGND VGND VPWR VPWR sky130_fd_sc_hd__decap_3
XFILLER_32_185 VGND VGND VPWR VPWR sky130_fd_sc_hd__decap_3
XFILLER_15_108 VGND VGND VPWR VPWR sky130_fd_sc_hd__decap_3
XFILLER_23_130 VGND VGND VPWR VPWR sky130_fd_sc_hd__decap_3
XFILLER_23_163 VGND VGND VPWR VPWR sky130_fd_sc_hd__decap_3
XFILLER_23_185 VGND VGND VPWR VPWR sky130_fd_sc_hd__decap_3
XFILLER_2_3 VGND VGND VPWR VPWR sky130_fd_sc_hd__decap_3
XFILLER_14_141 VGND VGND VPWR VPWR sky130_fd_sc_hd__decap_3
XFILLER_14_174 VGND VGND VPWR VPWR sky130_fd_sc_hd__decap_3
Xinput13 load_hour_tens_i[2] VGND VGND VPWR VPWR _437_/B sky130_fd_sc_hd__clkdlybuf4s25_1
X_317_ _317_/A VGND VGND VPWR VPWR _317_/Y sky130_fd_sc_hd__inv_2
Xinput24 load_sec_ones_i[1] VGND VGND VPWR VPWR _605_/A1 sky130_fd_sc_hd__clkdlybuf4s25_1
XFILLER_35_3 VGND VGND VPWR VPWR sky130_fd_sc_hd__decap_3
XFILLER_37_244 VGND VGND VPWR VPWR sky130_fd_sc_hd__fill_1
XFILLER_20_144 VGND VGND VPWR VPWR sky130_fd_sc_hd__decap_3
XFILLER_32_18 VGND VGND VPWR VPWR sky130_fd_sc_hd__decap_3
XTAP_TAPCELL_ROW_7_115 VGND VPWR sky130_fd_sc_hd__tapvpwrvgnd_1
XFILLER_28_200 VGND VGND VPWR VPWR sky130_fd_sc_hd__decap_3
Xclkbuf_4_5_0_clk clkbuf_0_clk/X VGND VGND VPWR VPWR _665_/CLK sky130_fd_sc_hd__clkbuf_8
XTAP_TAPCELL_ROW_13_139 VGND VPWR sky130_fd_sc_hd__tapvpwrvgnd_1
XFILLER_11_166 VGND VGND VPWR VPWR sky130_fd_sc_hd__fill_2
XFILLER_22_73 VGND VGND VPWR VPWR sky130_fd_sc_hd__decap_3
XTAP_TAPCELL_ROW_21_172 VGND VPWR sky130_fd_sc_hd__tapvpwrvgnd_1
XFILLER_7_137 VGND VGND VPWR VPWR sky130_fd_sc_hd__decap_3
XFILLER_19_222 VGND VGND VPWR VPWR sky130_fd_sc_hd__fill_2
XFILLER_6_192 VGND VGND VPWR VPWR sky130_fd_sc_hd__decap_3
XFILLER_25_225 VGND VGND VPWR VPWR sky130_fd_sc_hd__decap_3
XFILLER_40_228 VGND VGND VPWR VPWR sky130_fd_sc_hd__decap_3
XFILLER_40_217 VGND VGND VPWR VPWR sky130_fd_sc_hd__decap_3
X_582_ _604_/A _614_/A _614_/B VGND VGND VPWR VPWR _585_/A sky130_fd_sc_hd__o21a_2
X_651_ _653_/CLK _651_/D fanout84/X VGND VGND VPWR VPWR _651_/Q sky130_fd_sc_hd__dfrtp_2
XFILLER_31_228 VGND VGND VPWR VPWR sky130_fd_sc_hd__fill_1
XFILLER_3_140 VGND VGND VPWR VPWR sky130_fd_sc_hd__decap_3
XFILLER_38_17 VGND VGND VPWR VPWR sky130_fd_sc_hd__decap_3
XFILLER_13_206 VGND VGND VPWR VPWR sky130_fd_sc_hd__decap_3
XFILLER_13_228 VGND VGND VPWR VPWR sky130_fd_sc_hd__fill_1
XFILLER_28_83 VGND VGND VPWR VPWR sky130_fd_sc_hd__fill_1
X_634_ _669_/CLK _634_/D fanout95/X VGND VGND VPWR VPWR _634_/Q sky130_fd_sc_hd__dfrtp_2
X_703_ _703_/CLK _703_/D load_slew89/X VGND VGND VPWR VPWR _703_/Q sky130_fd_sc_hd__dfrtp_2
XFILLER_28_94 VGND VGND VPWR VPWR sky130_fd_sc_hd__decap_3
X_565_ _574_/B _569_/B _566_/A _564_/B VGND VGND VPWR VPWR _565_/X sky130_fd_sc_hd__o211a_2
X_496_ _654_/Q _493_/X _495_/Y _522_/A VGND VGND VPWR VPWR _654_/D sky130_fd_sc_hd__o211a_2
XFILLER_5_21 VGND VGND VPWR VPWR sky130_fd_sc_hd__decap_3
XFILLER_5_54 VGND VGND VPWR VPWR sky130_fd_sc_hd__fill_2
XFILLER_10_209 VGND VGND VPWR VPWR sky130_fd_sc_hd__decap_3
XFILLER_40_18 VGND VGND VPWR VPWR sky130_fd_sc_hd__decap_3
XFILLER_40_29 VGND VGND VPWR VPWR sky130_fd_sc_hd__decap_3
X_350_ _680_/Q _328_/Y _633_/D _668_/Q _348_/X VGND VGND VPWR VPWR _350_/X sky130_fd_sc_hd__a221o_2
XFILLER_14_41 VGND VGND VPWR VPWR sky130_fd_sc_hd__decap_3
XFILLER_14_63 VGND VGND VPWR VPWR sky130_fd_sc_hd__decap_3
XFILLER_14_96 VGND VGND VPWR VPWR sky130_fd_sc_hd__decap_3
XFILLER_5_202 VGND VGND VPWR VPWR sky130_fd_sc_hd__decap_3
XFILLER_30_73 VGND VGND VPWR VPWR sky130_fd_sc_hd__decap_3
X_617_ _684_/Q _703_/Q VGND VGND VPWR VPWR _618_/B sky130_fd_sc_hd__or2_2
X_548_ _552_/B _548_/A2 _552_/C _552_/A VGND VGND VPWR VPWR _548_/X sky130_fd_sc_hd__a211o_2
X_479_ _485_/C VGND VGND VPWR VPWR _479_/Y sky130_fd_sc_hd__inv_2
XFILLER_35_18 VGND VGND VPWR VPWR sky130_fd_sc_hd__decap_3
X_402_ _692_/Q _691_/Q VGND VGND VPWR VPWR _408_/D sky130_fd_sc_hd__and2_2
X_333_ _333_/A _684_/Q _685_/Q VGND VGND VPWR VPWR _333_/Y sky130_fd_sc_hd__nor3b_2
XFILLER_2_44 VGND VGND VPWR VPWR sky130_fd_sc_hd__decap_3
XFILLER_17_172 VGND VGND VPWR VPWR sky130_fd_sc_hd__decap_3
XFILLER_2_88 VGND VGND VPWR VPWR sky130_fd_sc_hd__decap_3
XFILLER_32_120 VGND VGND VPWR VPWR sky130_fd_sc_hd__decap_3
XFILLER_32_197 VGND VGND VPWR VPWR sky130_fd_sc_hd__decap_3
XFILLER_32_164 VGND VGND VPWR VPWR sky130_fd_sc_hd__decap_3
XFILLER_11_42 VGND VGND VPWR VPWR sky130_fd_sc_hd__decap_3
XFILLER_14_131 VGND VGND VPWR VPWR sky130_fd_sc_hd__decap_3
XFILLER_36_94 VGND VGND VPWR VPWR sky130_fd_sc_hd__decap_3
XFILLER_36_83 VGND VGND VPWR VPWR sky130_fd_sc_hd__fill_1
XFILLER_14_197 VGND VGND VPWR VPWR sky130_fd_sc_hd__decap_3
Xinput25 load_sec_ones_i[2] VGND VGND VPWR VPWR _611_/A1 sky130_fd_sc_hd__clkdlybuf4s25_1
Xinput14 load_hour_tens_i[3] VGND VGND VPWR VPWR _437_/A sky130_fd_sc_hd__clkdlybuf4s25_1
X_316_ _316_/A VGND VGND VPWR VPWR _316_/Y sky130_fd_sc_hd__inv_2
XPHY_EDGE_ROW_26_Left_67 VGND VGND VPWR VPWR sky130_fd_sc_hd__decap_3
XFILLER_28_3 VGND VGND VPWR VPWR sky130_fd_sc_hd__decap_3
XFILLER_20_134 VGND VGND VPWR VPWR sky130_fd_sc_hd__decap_3
XFILLER_20_156 VGND VGND VPWR VPWR sky130_fd_sc_hd__decap_3
XTAP_TAPCELL_ROW_7_116 VGND VPWR sky130_fd_sc_hd__tapvpwrvgnd_1
Xjam_digital_top_103 VGND VGND VPWR VPWR jam_digital_top_103/HI hour_tens_o[2] sky130_fd_sc_hd__conb_1
XTAP_TAPCELL_ROW_38_240 VGND VPWR sky130_fd_sc_hd__tapvpwrvgnd_1
XFILLER_11_101 VGND VGND VPWR VPWR sky130_fd_sc_hd__decap_3
XFILLER_11_178 VGND VGND VPWR VPWR sky130_fd_sc_hd__decap_3
XFILLER_22_41 VGND VGND VPWR VPWR sky130_fd_sc_hd__decap_3
XFILLER_7_116 VGND VGND VPWR VPWR sky130_fd_sc_hd__decap_3
XFILLER_22_85 VGND VGND VPWR VPWR sky130_fd_sc_hd__decap_3
XTAP_TAPCELL_ROW_21_173 VGND VPWR sky130_fd_sc_hd__tapvpwrvgnd_1
XFILLER_14_9 VGND VGND VPWR VPWR sky130_fd_sc_hd__decap_3
XFILLER_8_98 VGND VGND VPWR VPWR sky130_fd_sc_hd__fill_1
XFILLER_8_32 VGND VGND VPWR VPWR sky130_fd_sc_hd__decap_3
XFILLER_8_21 VGND VGND VPWR VPWR sky130_fd_sc_hd__decap_3
XFILLER_25_204 VGND VGND VPWR VPWR sky130_fd_sc_hd__decap_3
XFILLER_4_108 VGND VGND VPWR VPWR sky130_fd_sc_hd__decap_3
X_650_ _653_/CLK _650_/D fanout82/X VGND VGND VPWR VPWR _650_/Q sky130_fd_sc_hd__dfrtp_2
X_581_ _705_/Q _313_/Y _604_/A _704_/Q VGND VGND VPWR VPWR _614_/B sky130_fd_sc_hd__a211o_2
XFILLER_3_152 VGND VGND VPWR VPWR sky130_fd_sc_hd__fill_2
XFILLER_22_218 VGND VGND VPWR VPWR sky130_fd_sc_hd__fill_1
Xclkbuf_4_4_0_clk clkbuf_0_clk/X VGND VGND VPWR VPWR _667_/CLK sky130_fd_sc_hd__clkbuf_8
XPHY_EDGE_ROW_29_Left_70 VGND VGND VPWR VPWR sky130_fd_sc_hd__decap_3
XPHY_EDGE_ROW_13_Left_54 VGND VGND VPWR VPWR sky130_fd_sc_hd__decap_3
XFILLER_38_29 VGND VGND VPWR VPWR sky130_fd_sc_hd__decap_3
XFILLER_0_100 VGND VGND VPWR VPWR sky130_fd_sc_hd__decap_3
XFILLER_0_122 VGND VGND VPWR VPWR sky130_fd_sc_hd__fill_1
XFILLER_0_144 VGND VGND VPWR VPWR sky130_fd_sc_hd__fill_1
XFILLER_28_40 VGND VGND VPWR VPWR sky130_fd_sc_hd__decap_3
X_633_ _675_/CLK _633_/D _630_/SET_B VGND VGND VPWR VPWR _633_/Q sky130_fd_sc_hd__dfrtp_2
X_702_ _708_/CLK _702_/D load_slew89/X VGND VGND VPWR VPWR _702_/Q sky130_fd_sc_hd__dfrtp_2
X_564_ _564_/A _564_/B VGND VGND VPWR VPWR _564_/Y sky130_fd_sc_hd__nand2_2
X_495_ _654_/Q _512_/C _498_/D VGND VGND VPWR VPWR _495_/Y sky130_fd_sc_hd__nand3_2
XFILLER_8_200 VGND VGND VPWR VPWR sky130_fd_sc_hd__decap_3
XFILLER_8_222 VGND VGND VPWR VPWR sky130_fd_sc_hd__fill_2
XFILLER_5_33 VGND VGND VPWR VPWR sky130_fd_sc_hd__decap_3
XFILLER_10_3 VGND VGND VPWR VPWR sky130_fd_sc_hd__decap_3
XFILLER_5_99 VGND VGND VPWR VPWR sky130_fd_sc_hd__decap_3
XFILLER_5_66 VGND VGND VPWR VPWR sky130_fd_sc_hd__decap_3
XFILLER_38_192 VGND VGND VPWR VPWR sky130_fd_sc_hd__decap_3
XFILLER_5_225 VGND VGND VPWR VPWR sky130_fd_sc_hd__fill_1
XFILLER_30_52 VGND VGND VPWR VPWR sky130_fd_sc_hd__decap_3
XFILLER_30_85 VGND VGND VPWR VPWR sky130_fd_sc_hd__decap_3
X_547_ _564_/A _545_/B _573_/S VGND VGND VPWR VPWR _550_/A sky130_fd_sc_hd__o21ai_2
X_616_ _684_/Q _703_/Q VGND VGND VPWR VPWR _618_/A sky130_fd_sc_hd__nand2_2
X_478_ _649_/Q _478_/B _504_/C VGND VGND VPWR VPWR _485_/C sky130_fd_sc_hd__and3_2
XFILLER_18_129 VGND VGND VPWR VPWR sky130_fd_sc_hd__decap_3
X_401_ _691_/Q _408_/C _401_/B1 VGND VGND VPWR VPWR _404_/B sky130_fd_sc_hd__a21oi_2
XFILLER_25_85 VGND VGND VPWR VPWR sky130_fd_sc_hd__decap_3
XFILLER_26_195 VGND VGND VPWR VPWR sky130_fd_sc_hd__fill_1
X_332_ _665_/Q _634_/D VGND VGND VPWR VPWR _332_/Y sky130_fd_sc_hd__nand2_2
XFILLER_2_12 VGND VGND VPWR VPWR sky130_fd_sc_hd__decap_3
XFILLER_2_56 VGND VGND VPWR VPWR sky130_fd_sc_hd__decap_3
XFILLER_17_184 VGND VGND VPWR VPWR sky130_fd_sc_hd__fill_1
XFILLER_17_195 VGND VGND VPWR VPWR sky130_fd_sc_hd__decap_3
XFILLER_32_176 VGND VGND VPWR VPWR sky130_fd_sc_hd__decap_3
XFILLER_23_110 VGND VGND VPWR VPWR sky130_fd_sc_hd__fill_2
XFILLER_23_176 VGND VGND VPWR VPWR sky130_fd_sc_hd__decap_3
XFILLER_11_54 VGND VGND VPWR VPWR sky130_fd_sc_hd__fill_2
XFILLER_11_76 VGND VGND VPWR VPWR sky130_fd_sc_hd__fill_2
XFILLER_11_98 VGND VGND VPWR VPWR sky130_fd_sc_hd__decap_3
XPHY_EDGE_ROW_1_Left_42 VGND VGND VPWR VPWR sky130_fd_sc_hd__decap_3
Xinput26 load_sec_ones_i[3] VGND VGND VPWR VPWR _603_/B sky130_fd_sc_hd__clkdlybuf4s25_1
Xinput15 load_min_ones_i[0] VGND VGND VPWR VPWR _567_/A2 sky130_fd_sc_hd__clkdlybuf4s25_1
X_315_ _315_/A VGND VGND VPWR VPWR _315_/Y sky130_fd_sc_hd__inv_2
XTAP_TAPCELL_ROW_24_182 VGND VPWR sky130_fd_sc_hd__tapvpwrvgnd_1
XFILLER_28_213 VGND VGND VPWR VPWR sky130_fd_sc_hd__decap_3
XTAP_TAPCELL_ROW_7_117 VGND VPWR sky130_fd_sc_hd__tapvpwrvgnd_1
Xjam_digital_top_104 VGND VGND VPWR VPWR jam_digital_top_104/HI hour_tens_o[3] sky130_fd_sc_hd__conb_1
XTAP_TAPCELL_ROW_38_241 VGND VPWR sky130_fd_sc_hd__tapvpwrvgnd_1
XFILLER_11_113 VGND VGND VPWR VPWR sky130_fd_sc_hd__decap_3
XFILLER_7_128 VGND VGND VPWR VPWR sky130_fd_sc_hd__decap_3
XFILLER_19_213 VGND VGND VPWR VPWR sky130_fd_sc_hd__decap_3
XFILLER_8_44 VGND VGND VPWR VPWR sky130_fd_sc_hd__decap_3
XFILLER_6_161 VGND VGND VPWR VPWR sky130_fd_sc_hd__decap_3
XFILLER_25_216 VGND VGND VPWR VPWR sky130_fd_sc_hd__decap_3
XFILLER_40_208 VGND VGND VPWR VPWR sky130_fd_sc_hd__decap_3
X_580_ _580_/A1 _550_/A _575_/X _579_/Y VGND VGND VPWR VPWR _675_/D sky130_fd_sc_hd__a31o_2
XFILLER_3_131 VGND VGND VPWR VPWR sky130_fd_sc_hd__decap_3
XTAP_TAPCELL_ROW_32_214 VGND VPWR sky130_fd_sc_hd__tapvpwrvgnd_1
XPHY_EDGE_ROW_17_Right_17 VGND VGND VPWR VPWR sky130_fd_sc_hd__decap_3
XFILLER_0_134 VGND VGND VPWR VPWR sky130_fd_sc_hd__decap_3
XPHY_EDGE_ROW_26_Right_26 VGND VGND VPWR VPWR sky130_fd_sc_hd__decap_3
XFILLER_28_52 VGND VGND VPWR VPWR sky130_fd_sc_hd__fill_2
XFILLER_28_85 VGND VGND VPWR VPWR sky130_fd_sc_hd__decap_3
X_563_ _550_/A _561_/Y _562_/X _552_/A VGND VGND VPWR VPWR _671_/D sky130_fd_sc_hd__o211a_2
X_632_ _675_/CLK _632_/D _630_/SET_B VGND VGND VPWR VPWR _632_/Q sky130_fd_sc_hd__dfrtp_2
X_701_ _705_/CLK _701_/D fanout86/X VGND VGND VPWR VPWR _701_/Q sky130_fd_sc_hd__dfrtp_2
X_494_ _493_/X _499_/B _494_/C VGND VGND VPWR VPWR _653_/D sky130_fd_sc_hd__and3b_2
XPHY_EDGE_ROW_35_Right_35 VGND VGND VPWR VPWR sky130_fd_sc_hd__decap_3
XPHY_EDGE_ROW_30_Left_71 VGND VGND VPWR VPWR sky130_fd_sc_hd__decap_3
XFILLER_5_45 VGND VGND VPWR VPWR sky130_fd_sc_hd__decap_3
XFILLER_5_12 VGND VGND VPWR VPWR sky130_fd_sc_hd__decap_3
XFILLER_38_160 VGND VGND VPWR VPWR sky130_fd_sc_hd__decap_3
XFILLER_14_76 VGND VGND VPWR VPWR sky130_fd_sc_hd__fill_1
XFILLER_5_215 VGND VGND VPWR VPWR sky130_fd_sc_hd__fill_1
XFILLER_30_97 VGND VGND VPWR VPWR sky130_fd_sc_hd__decap_3
XFILLER_30_64 VGND VGND VPWR VPWR sky130_fd_sc_hd__decap_3
Xclkbuf_4_3_0_clk clkbuf_0_clk/X VGND VGND VPWR VPWR _684_/CLK sky130_fd_sc_hd__clkbuf_8
XFILLER_39_51 VGND VGND VPWR VPWR sky130_fd_sc_hd__decap_3
X_546_ _564_/A _545_/B _573_/S VGND VGND VPWR VPWR _556_/A sky130_fd_sc_hd__o21a_2
X_615_ _615_/A1 _610_/Y _614_/Y _613_/Y VGND VGND VPWR VPWR _683_/D sky130_fd_sc_hd__a31o_2
X_477_ _477_/A _506_/C _506_/D VGND VGND VPWR VPWR _493_/C sky130_fd_sc_hd__and3_2
XFILLER_35_130 VGND VGND VPWR VPWR sky130_fd_sc_hd__decap_3
XFILLER_4_9 VGND VGND VPWR VPWR sky130_fd_sc_hd__decap_3
XFILLER_25_53 VGND VGND VPWR VPWR sky130_fd_sc_hd__decap_3
XFILLER_26_130 VGND VGND VPWR VPWR sky130_fd_sc_hd__fill_2
XFILLER_26_141 VGND VGND VPWR VPWR sky130_fd_sc_hd__decap_3
X_400_ _400_/A1 _408_/C _399_/Y VGND VGND VPWR VPWR _691_/D sky130_fd_sc_hd__a21oi_2
X_331_ _685_/Q _684_/Q _686_/Q VGND VGND VPWR VPWR _634_/D sky130_fd_sc_hd__nor3b_2
XFILLER_25_97 VGND VGND VPWR VPWR sky130_fd_sc_hd__decap_3
XFILLER_37_9 VGND VGND VPWR VPWR sky130_fd_sc_hd__decap_3
XFILLER_2_24 VGND VGND VPWR VPWR sky130_fd_sc_hd__decap_3
XFILLER_2_35 VGND VGND VPWR VPWR sky130_fd_sc_hd__decap_3
X_529_ _552_/A _529_/B _529_/C input8/X VGND VGND VPWR VPWR _529_/X sky130_fd_sc_hd__or4b_2
XFILLER_32_188 VGND VGND VPWR VPWR sky130_fd_sc_hd__decap_3
XFILLER_23_133 VGND VGND VPWR VPWR sky130_fd_sc_hd__decap_3
XFILLER_23_166 VGND VGND VPWR VPWR sky130_fd_sc_hd__fill_2
XFILLER_23_188 VGND VGND VPWR VPWR sky130_fd_sc_hd__decap_3
XFILLER_11_22 VGND VGND VPWR VPWR sky130_fd_sc_hd__decap_3
XFILLER_11_33 VGND VGND VPWR VPWR sky130_fd_sc_hd__decap_3
XFILLER_11_66 VGND VGND VPWR VPWR sky130_fd_sc_hd__fill_1
XFILLER_2_6 VGND VGND VPWR VPWR sky130_fd_sc_hd__decap_3
XFILLER_14_111 VGND VGND VPWR VPWR sky130_fd_sc_hd__decap_3
XFILLER_14_144 VGND VGND VPWR VPWR sky130_fd_sc_hd__fill_1
XFILLER_14_177 VGND VGND VPWR VPWR sky130_fd_sc_hd__fill_2
X_314_ _529_/C VGND VGND VPWR VPWR _314_/Y sky130_fd_sc_hd__inv_2
XFILLER_36_85 VGND VGND VPWR VPWR sky130_fd_sc_hd__decap_3
Xinput27 load_sec_tens_i[0] VGND VGND VPWR VPWR input27/X sky130_fd_sc_hd__clkdlybuf4s25_1
Xinput16 load_min_ones_i[1] VGND VGND VPWR VPWR _569_/B sky130_fd_sc_hd__clkdlybuf4s25_1
XTAP_TAPCELL_ROW_24_183 VGND VPWR sky130_fd_sc_hd__tapvpwrvgnd_1
XFILLER_35_6 VGND VGND VPWR VPWR sky130_fd_sc_hd__decap_3
XFILLER_37_225 VGND VGND VPWR VPWR sky130_fd_sc_hd__decap_3
XFILLER_20_147 VGND VGND VPWR VPWR sky130_fd_sc_hd__decap_3
XFILLER_28_203 VGND VGND VPWR VPWR sky130_fd_sc_hd__fill_2
XFILLER_11_125 VGND VGND VPWR VPWR sky130_fd_sc_hd__decap_3
XFILLER_11_169 VGND VGND VPWR VPWR sky130_fd_sc_hd__decap_3
XFILLER_22_32 VGND VGND VPWR VPWR sky130_fd_sc_hd__fill_1
XFILLER_0_3 VGND VGND VPWR VPWR sky130_fd_sc_hd__decap_3
XFILLER_19_225 VGND VGND VPWR VPWR sky130_fd_sc_hd__decap_3
XFILLER_8_12 VGND VGND VPWR VPWR sky130_fd_sc_hd__decap_3
XFILLER_10_180 VGND VGND VPWR VPWR sky130_fd_sc_hd__fill_2
XFILLER_10_191 VGND VGND VPWR VPWR sky130_fd_sc_hd__decap_3
XFILLER_6_195 VGND VGND VPWR VPWR sky130_fd_sc_hd__fill_1
XFILLER_33_3 VGND VGND VPWR VPWR sky130_fd_sc_hd__decap_3
XFILLER_25_228 VGND VGND VPWR VPWR sky130_fd_sc_hd__fill_1
XFILLER_3_143 VGND VGND VPWR VPWR sky130_fd_sc_hd__decap_3
XFILLER_33_97 VGND VGND VPWR VPWR sky130_fd_sc_hd__decap_3
XTAP_TAPCELL_ROW_32_215 VGND VPWR sky130_fd_sc_hd__tapvpwrvgnd_1
XFILLER_13_209 VGND VGND VPWR VPWR sky130_fd_sc_hd__decap_3
XFILLER_0_113 VGND VGND VPWR VPWR sky130_fd_sc_hd__decap_3
X_700_ _708_/CLK _700_/D fanout88/X VGND VGND VPWR VPWR _700_/Q sky130_fd_sc_hd__dfrtp_2
XFILLER_28_97 VGND VGND VPWR VPWR sky130_fd_sc_hd__decap_3
X_562_ _556_/A _561_/B _671_/Q VGND VGND VPWR VPWR _562_/X sky130_fd_sc_hd__a21o_2
X_631_ _675_/CLK _631_/D _630_/SET_B VGND VGND VPWR VPWR _631_/Q sky130_fd_sc_hd__dfrtp_2
X_493_ _653_/Q _506_/B _493_/C VGND VGND VPWR VPWR _493_/X sky130_fd_sc_hd__and3_2
XFILLER_5_57 VGND VGND VPWR VPWR sky130_fd_sc_hd__decap_3
XFILLER_5_24 VGND VGND VPWR VPWR sky130_fd_sc_hd__decap_3
XFILLER_14_44 VGND VGND VPWR VPWR sky130_fd_sc_hd__fill_1
XFILLER_14_66 VGND VGND VPWR VPWR sky130_fd_sc_hd__fill_2
XFILLER_14_99 VGND VGND VPWR VPWR sky130_fd_sc_hd__decap_3
XFILLER_5_205 VGND VGND VPWR VPWR sky130_fd_sc_hd__fill_1
XFILLER_30_76 VGND VGND VPWR VPWR sky130_fd_sc_hd__decap_3
XFILLER_30_21 VGND VGND VPWR VPWR sky130_fd_sc_hd__decap_3
XFILLER_39_30 VGND VGND VPWR VPWR sky130_fd_sc_hd__fill_1
X_545_ _564_/A _545_/B VGND VGND VPWR VPWR _545_/Y sky130_fd_sc_hd__nor2_2
X_614_ _614_/A _614_/B VGND VGND VPWR VPWR _614_/Y sky130_fd_sc_hd__nand2_2
X_476_ _646_/Q _645_/Q _648_/Q _647_/Q VGND VGND VPWR VPWR _506_/D sky130_fd_sc_hd__and4_2
XFILLER_35_186 VGND VGND VPWR VPWR sky130_fd_sc_hd__decap_3
XFILLER_26_186 VGND VGND VPWR VPWR sky130_fd_sc_hd__decap_3
X_330_ _681_/Q _328_/Y _633_/D _669_/Q VGND VGND VPWR VPWR _337_/A sky130_fd_sc_hd__a22o_2
XFILLER_17_131 VGND VGND VPWR VPWR sky130_fd_sc_hd__decap_3
XFILLER_2_47 VGND VGND VPWR VPWR sky130_fd_sc_hd__decap_3
XFILLER_17_175 VGND VGND VPWR VPWR sky130_fd_sc_hd__decap_3
X_528_ _664_/Q _532_/S _526_/X _527_/X VGND VGND VPWR VPWR _664_/D sky130_fd_sc_hd__o211a_2
X_459_ _384_/X _389_/X _499_/B VGND VGND VPWR VPWR _515_/B sky130_fd_sc_hd__a21bo_2
XFILLER_32_167 VGND VGND VPWR VPWR sky130_fd_sc_hd__decap_3
XFILLER_32_123 VGND VGND VPWR VPWR sky130_fd_sc_hd__decap_3
Xclkbuf_4_2_0_clk clkbuf_0_clk/X VGND VGND VPWR VPWR _642_/CLK sky130_fd_sc_hd__clkbuf_8
XFILLER_11_45 VGND VGND VPWR VPWR sky130_fd_sc_hd__decap_3
XFILLER_14_134 VGND VGND VPWR VPWR sky130_fd_sc_hd__decap_3
X_313_ _708_/Q VGND VGND VPWR VPWR _313_/Y sky130_fd_sc_hd__inv_2
XTAP_TAPCELL_ROW_24_184 VGND VPWR sky130_fd_sc_hd__tapvpwrvgnd_1
XFILLER_36_97 VGND VGND VPWR VPWR sky130_fd_sc_hd__decap_3
Xinput28 load_sec_tens_i[1] VGND VGND VPWR VPWR _318_/A sky130_fd_sc_hd__clkdlybuf4s25_1
Xinput17 load_min_ones_i[2] VGND VGND VPWR VPWR _574_/B sky130_fd_sc_hd__clkdlybuf4s25_1
XFILLER_28_6 VGND VGND VPWR VPWR sky130_fd_sc_hd__decap_3
XFILLER_20_137 VGND VGND VPWR VPWR sky130_fd_sc_hd__decap_3
XFILLER_20_159 VGND VGND VPWR VPWR sky130_fd_sc_hd__decap_3
XFILLER_11_104 VGND VGND VPWR VPWR sky130_fd_sc_hd__decap_3
XFILLER_22_44 VGND VGND VPWR VPWR sky130_fd_sc_hd__decap_3
XFILLER_22_88 VGND VGND VPWR VPWR sky130_fd_sc_hd__decap_3
XFILLER_7_119 VGND VGND VPWR VPWR sky130_fd_sc_hd__decap_3
XFILLER_19_204 VGND VGND VPWR VPWR sky130_fd_sc_hd__decap_3
XFILLER_8_68 VGND VGND VPWR VPWR sky130_fd_sc_hd__decap_3
XFILLER_8_35 VGND VGND VPWR VPWR sky130_fd_sc_hd__decap_3
XFILLER_8_24 VGND VGND VPWR VPWR sky130_fd_sc_hd__decap_3
XFILLER_6_141 VGND VGND VPWR VPWR sky130_fd_sc_hd__decap_3
XFILLER_26_3 VGND VGND VPWR VPWR sky130_fd_sc_hd__fill_2
XFILLER_25_207 VGND VGND VPWR VPWR sky130_fd_sc_hd__decap_3
XTAP_TAPCELL_ROW_3_100 VGND VPWR sky130_fd_sc_hd__tapvpwrvgnd_1
XFILLER_17_66 VGND VGND VPWR VPWR sky130_fd_sc_hd__decap_3
XFILLER_3_177 VGND VGND VPWR VPWR sky130_fd_sc_hd__decap_3
XFILLER_3_122 VGND VGND VPWR VPWR sky130_fd_sc_hd__decap_3
XTAP_TAPCELL_ROW_32_216 VGND VPWR sky130_fd_sc_hd__tapvpwrvgnd_1
XFILLER_0_91 VGND VGND VPWR VPWR sky130_fd_sc_hd__decap_3
XPHY_EDGE_ROW_3_Right_3 VGND VGND VPWR VPWR sky130_fd_sc_hd__decap_3
XFILLER_0_103 VGND VGND VPWR VPWR sky130_fd_sc_hd__decap_3
XFILLER_28_21 VGND VGND VPWR VPWR sky130_fd_sc_hd__decap_3
XFILLER_28_32 VGND VGND VPWR VPWR sky130_fd_sc_hd__fill_1
XFILLER_28_43 VGND VGND VPWR VPWR sky130_fd_sc_hd__decap_3
X_630_ _675_/CLK _630_/D _630_/SET_B VGND VGND VPWR VPWR _630_/Q sky130_fd_sc_hd__dfstp_2
X_561_ _671_/Q _561_/B VGND VGND VPWR VPWR _561_/Y sky130_fd_sc_hd__nand2_2
X_492_ _506_/B _504_/B _504_/C VGND VGND VPWR VPWR _498_/D sky130_fd_sc_hd__and3_2
XFILLER_5_36 VGND VGND VPWR VPWR sky130_fd_sc_hd__decap_3
XFILLER_10_6 VGND VGND VPWR VPWR sky130_fd_sc_hd__decap_3
XPHY_EDGE_ROW_17_Left_58 VGND VGND VPWR VPWR sky130_fd_sc_hd__decap_3
XFILLER_38_195 VGND VGND VPWR VPWR sky130_fd_sc_hd__fill_1
XFILLER_14_12 VGND VGND VPWR VPWR sky130_fd_sc_hd__fill_2
XFILLER_30_88 VGND VGND VPWR VPWR sky130_fd_sc_hd__decap_3
XFILLER_30_55 VGND VGND VPWR VPWR sky130_fd_sc_hd__decap_3
XFILLER_29_140 VGND VGND VPWR VPWR sky130_fd_sc_hd__decap_3
XFILLER_29_195 VGND VGND VPWR VPWR sky130_fd_sc_hd__fill_2
X_613_ _603_/A _683_/Q _603_/Y _610_/Y VGND VGND VPWR VPWR _613_/Y sky130_fd_sc_hd__a211oi_2
X_544_ _704_/Q _614_/A _376_/C _543_/X _564_/A VGND VGND VPWR VPWR _573_/S sky130_fd_sc_hd__a311o_2
X_475_ _316_/Y _469_/Y _474_/Y VGND VGND VPWR VPWR _648_/D sky130_fd_sc_hd__a21oi_2
XFILLER_35_121 VGND VGND VPWR VPWR sky130_fd_sc_hd__decap_3
XFILLER_25_88 VGND VGND VPWR VPWR sky130_fd_sc_hd__decap_3
XFILLER_1_231 VGND VGND VPWR VPWR sky130_fd_sc_hd__decap_3
XFILLER_2_15 VGND VGND VPWR VPWR sky130_fd_sc_hd__decap_3
XFILLER_2_59 VGND VGND VPWR VPWR sky130_fd_sc_hd__decap_3
XFILLER_17_110 VGND VGND VPWR VPWR sky130_fd_sc_hd__fill_2
X_527_ _533_/A _527_/B _664_/Q VGND VGND VPWR VPWR _527_/X sky130_fd_sc_hd__or3b_2
XFILLER_17_198 VGND VGND VPWR VPWR sky130_fd_sc_hd__fill_1
X_458_ _458_/A _458_/B _458_/C VGND VGND VPWR VPWR _643_/D sky130_fd_sc_hd__and3_2
X_389_ _385_/X _386_/X _389_/C _389_/D VGND VGND VPWR VPWR _389_/X sky130_fd_sc_hd__and4bb_2
XFILLER_32_179 VGND VGND VPWR VPWR sky130_fd_sc_hd__decap_3
XFILLER_23_113 VGND VGND VPWR VPWR sky130_fd_sc_hd__decap_3
XFILLER_23_124 VGND VGND VPWR VPWR sky130_fd_sc_hd__decap_3
XFILLER_23_157 VGND VGND VPWR VPWR sky130_fd_sc_hd__decap_3
XFILLER_23_179 VGND VGND VPWR VPWR sky130_fd_sc_hd__decap_3
XTAP_TAPCELL_ROW_18_160 VGND VPWR sky130_fd_sc_hd__tapvpwrvgnd_1
XFILLER_11_57 VGND VGND VPWR VPWR sky130_fd_sc_hd__fill_1
XFILLER_31_190 VGND VGND VPWR VPWR sky130_fd_sc_hd__decap_3
XFILLER_14_102 VGND VGND VPWR VPWR sky130_fd_sc_hd__decap_3
XFILLER_36_21 VGND VGND VPWR VPWR sky130_fd_sc_hd__decap_3
Xinput18 load_min_ones_i[3] VGND VGND VPWR VPWR _564_/B sky130_fd_sc_hd__clkdlybuf4s25_1
X_312_ _674_/Q VGND VGND VPWR VPWR _576_/A sky130_fd_sc_hd__inv_2
XTAP_TAPCELL_ROW_24_185 VGND VPWR sky130_fd_sc_hd__tapvpwrvgnd_1
Xinput29 load_sec_tens_i[2] VGND VGND VPWR VPWR _588_/B sky130_fd_sc_hd__clkdlybuf4s25_1
XFILLER_13_190 VGND VGND VPWR VPWR sky130_fd_sc_hd__decap_3
XFILLER_9_194 VGND VGND VPWR VPWR sky130_fd_sc_hd__decap_3
XFILLER_9_172 VGND VGND VPWR VPWR sky130_fd_sc_hd__decap_3
XFILLER_9_161 VGND VGND VPWR VPWR sky130_fd_sc_hd__decap_3
XFILLER_11_116 VGND VGND VPWR VPWR sky130_fd_sc_hd__fill_1
XFILLER_22_23 VGND VGND VPWR VPWR sky130_fd_sc_hd__decap_3
XPHY_EDGE_ROW_5_Left_46 VGND VGND VPWR VPWR sky130_fd_sc_hd__decap_3
XFILLER_19_216 VGND VGND VPWR VPWR sky130_fd_sc_hd__decap_3
XFILLER_6_164 VGND VGND VPWR VPWR sky130_fd_sc_hd__decap_3
XFILLER_40_6 VGND VGND VPWR VPWR sky130_fd_sc_hd__decap_3
XFILLER_19_3 VGND VGND VPWR VPWR sky130_fd_sc_hd__decap_3
XFILLER_25_219 VGND VGND VPWR VPWR sky130_fd_sc_hd__decap_3
Xclkbuf_4_1_0_clk clkbuf_0_clk/X VGND VGND VPWR VPWR _713_/CLK sky130_fd_sc_hd__clkbuf_8
XFILLER_33_241 VGND VGND VPWR VPWR sky130_fd_sc_hd__decap_3
XTAP_TAPCELL_ROW_3_101 VGND VPWR sky130_fd_sc_hd__tapvpwrvgnd_1
XFILLER_3_134 VGND VGND VPWR VPWR sky130_fd_sc_hd__decap_3
XFILLER_3_101 VGND VGND VPWR VPWR sky130_fd_sc_hd__decap_3
XTAP_TAPCELL_ROW_32_217 VGND VPWR sky130_fd_sc_hd__tapvpwrvgnd_1
XFILLER_30_200 VGND VGND VPWR VPWR sky130_fd_sc_hd__decap_3
XTAP_TAPCELL_ROW_40_250 VGND VPWR sky130_fd_sc_hd__tapvpwrvgnd_1
XFILLER_0_81 VGND VGND VPWR VPWR sky130_fd_sc_hd__decap_3
XFILLER_0_137 VGND VGND VPWR VPWR sky130_fd_sc_hd__decap_3
XFILLER_28_88 VGND VGND VPWR VPWR sky130_fd_sc_hd__decap_3
X_560_ _560_/A1 _556_/X _559_/X VGND VGND VPWR VPWR _670_/D sky130_fd_sc_hd__o21ba_2
X_491_ _653_/Q _506_/A _507_/B _506_/C VGND VGND VPWR VPWR _512_/C sky130_fd_sc_hd__and4_2
XFILLER_5_15 VGND VGND VPWR VPWR sky130_fd_sc_hd__decap_3
XFILLER_5_48 VGND VGND VPWR VPWR sky130_fd_sc_hd__decap_3
X_689_ _711_/CLK _689_/D load_slew87/X VGND VGND VPWR VPWR _689_/Q sky130_fd_sc_hd__dfrtp_2
XPHY_EDGE_ROW_13_Right_13 VGND VGND VPWR VPWR sky130_fd_sc_hd__decap_3
XPHY_EDGE_ROW_22_Right_22 VGND VGND VPWR VPWR sky130_fd_sc_hd__decap_3
XPHY_EDGE_ROW_31_Right_31 VGND VGND VPWR VPWR sky130_fd_sc_hd__decap_3
XFILLER_38_141 VGND VGND VPWR VPWR sky130_fd_sc_hd__fill_2
XFILLER_38_130 VGND VGND VPWR VPWR sky130_fd_sc_hd__fill_1
XFILLER_14_35 VGND VGND VPWR VPWR sky130_fd_sc_hd__decap_3
XFILLER_30_12 VGND VGND VPWR VPWR sky130_fd_sc_hd__decap_3
XPHY_EDGE_ROW_40_Right_40 VGND VGND VPWR VPWR sky130_fd_sc_hd__decap_3
XFILLER_39_54 VGND VGND VPWR VPWR sky130_fd_sc_hd__fill_2
XFILLER_39_21 VGND VGND VPWR VPWR sky130_fd_sc_hd__decap_3
XFILLER_30_67 VGND VGND VPWR VPWR sky130_fd_sc_hd__decap_3
X_543_ _709_/Q _706_/Q VGND VGND VPWR VPWR _543_/X sky130_fd_sc_hd__and2b_2
X_612_ _612_/A1 _614_/B _611_/X VGND VGND VPWR VPWR _682_/D sky130_fd_sc_hd__o21a_2
XPHY_EDGE_ROW_34_Left_75 VGND VGND VPWR VPWR sky130_fd_sc_hd__decap_3
X_474_ _316_/Y _469_/Y _458_/A VGND VGND VPWR VPWR _474_/Y sky130_fd_sc_hd__o21ai_2
XFILLER_35_166 VGND VGND VPWR VPWR sky130_fd_sc_hd__fill_2
XFILLER_35_133 VGND VGND VPWR VPWR sky130_fd_sc_hd__decap_3
XFILLER_6_91 VGND VGND VPWR VPWR sky130_fd_sc_hd__fill_1
XFILLER_26_144 VGND VGND VPWR VPWR sky130_fd_sc_hd__fill_1
XFILLER_26_166 VGND VGND VPWR VPWR sky130_fd_sc_hd__fill_2
XFILLER_1_243 VGND VGND VPWR VPWR sky130_fd_sc_hd__fill_2
XFILLER_2_27 VGND VGND VPWR VPWR sky130_fd_sc_hd__fill_1
XFILLER_2_38 VGND VGND VPWR VPWR sky130_fd_sc_hd__decap_3
XFILLER_17_122 VGND VGND VPWR VPWR sky130_fd_sc_hd__decap_3
X_526_ _529_/C _529_/B _525_/X input7/X _552_/A VGND VGND VPWR VPWR _526_/X sky130_fd_sc_hd__a2111o_2
XTAP_TAPCELL_ROW_27_194 VGND VPWR sky130_fd_sc_hd__tapvpwrvgnd_1
X_457_ _457_/A _477_/A VGND VGND VPWR VPWR _458_/C sky130_fd_sc_hd__nand2_2
X_388_ _656_/Q _658_/Q _657_/Q _660_/Q VGND VGND VPWR VPWR _389_/D sky130_fd_sc_hd__and4_2
XTAP_TAPCELL_ROW_18_161 VGND VPWR sky130_fd_sc_hd__tapvpwrvgnd_1
XFILLER_11_25 VGND VGND VPWR VPWR sky130_fd_sc_hd__fill_1
XFILLER_11_36 VGND VGND VPWR VPWR sky130_fd_sc_hd__decap_3
XFILLER_2_9 VGND VGND VPWR VPWR sky130_fd_sc_hd__decap_3
XFILLER_14_114 VGND VGND VPWR VPWR sky130_fd_sc_hd__decap_3
XFILLER_36_88 VGND VGND VPWR VPWR sky130_fd_sc_hd__decap_3
XFILLER_36_77 VGND VGND VPWR VPWR sky130_fd_sc_hd__decap_3
Xinput19 load_min_tens_i[0] VGND VGND VPWR VPWR input19/X sky130_fd_sc_hd__clkdlybuf4s25_1
X_311_ _533_/A VGND VGND VPWR VPWR _603_/A sky130_fd_sc_hd__inv_2
XFILLER_35_9 VGND VGND VPWR VPWR sky130_fd_sc_hd__decap_3
XFILLER_37_228 VGND VGND VPWR VPWR sky130_fd_sc_hd__decap_3
X_509_ _658_/Q _510_/B VGND VGND VPWR VPWR _511_/B sky130_fd_sc_hd__or2_2
XPHY_EDGE_ROW_21_Left_62 VGND VGND VPWR VPWR sky130_fd_sc_hd__decap_3
XFILLER_9_140 VGND VGND VPWR VPWR sky130_fd_sc_hd__decap_3
XFILLER_11_128 VGND VGND VPWR VPWR sky130_fd_sc_hd__decap_3
XFILLER_0_6 VGND VGND VPWR VPWR sky130_fd_sc_hd__decap_3
XTAP_TAPCELL_ROW_6_110 VGND VPWR sky130_fd_sc_hd__tapvpwrvgnd_1
XFILLER_19_228 VGND VGND VPWR VPWR sky130_fd_sc_hd__fill_1
XFILLER_8_15 VGND VGND VPWR VPWR sky130_fd_sc_hd__decap_3
XFILLER_10_194 VGND VGND VPWR VPWR sky130_fd_sc_hd__fill_2
XTAP_TAPCELL_ROW_12_134 VGND VPWR sky130_fd_sc_hd__tapvpwrvgnd_1
XFILLER_6_132 VGND VGND VPWR VPWR sky130_fd_sc_hd__decap_3
XFILLER_33_6 VGND VGND VPWR VPWR sky130_fd_sc_hd__decap_3
XTAP_TAPCELL_ROW_35_226 VGND VPWR sky130_fd_sc_hd__tapvpwrvgnd_1
XFILLER_17_57 VGND VGND VPWR VPWR sky130_fd_sc_hd__fill_1
XFILLER_33_12 VGND VGND VPWR VPWR sky130_fd_sc_hd__decap_3
XFILLER_3_146 VGND VGND VPWR VPWR sky130_fd_sc_hd__decap_3
XFILLER_15_231 VGND VGND VPWR VPWR sky130_fd_sc_hd__decap_3
XTAP_TAPCELL_ROW_40_251 VGND VPWR sky130_fd_sc_hd__tapvpwrvgnd_1
XFILLER_31_3 VGND VGND VPWR VPWR sky130_fd_sc_hd__decap_3
XFILLER_0_60 VGND VGND VPWR VPWR sky130_fd_sc_hd__decap_3
XFILLER_9_80 VGND VGND VPWR VPWR sky130_fd_sc_hd__decap_3
XFILLER_0_116 VGND VGND VPWR VPWR sky130_fd_sc_hd__decap_3
XFILLER_28_12 VGND VGND VPWR VPWR sky130_fd_sc_hd__decap_3
X_490_ _506_/B _493_/C _653_/Q VGND VGND VPWR VPWR _494_/C sky130_fd_sc_hd__a21o_2
Xclkbuf_4_0_0_clk clkbuf_0_clk/X VGND VGND VPWR VPWR _653_/CLK sky130_fd_sc_hd__clkbuf_8
XFILLER_5_27 VGND VGND VPWR VPWR sky130_fd_sc_hd__decap_3
XFILLER_39_109 VGND VGND VPWR VPWR sky130_fd_sc_hd__decap_3
X_688_ _711_/CLK _688_/D load_slew87/X VGND VGND VPWR VPWR _688_/Q sky130_fd_sc_hd__dfrtp_2
XFILLER_30_79 VGND VGND VPWR VPWR sky130_fd_sc_hd__decap_3
XFILLER_30_46 VGND VGND VPWR VPWR sky130_fd_sc_hd__decap_3
XFILLER_30_24 VGND VGND VPWR VPWR sky130_fd_sc_hd__decap_3
XFILLER_29_131 VGND VGND VPWR VPWR sky130_fd_sc_hd__decap_3
X_542_ _542_/A1 _527_/B _540_/Y _541_/Y _538_/X VGND VGND VPWR VPWR _667_/D sky130_fd_sc_hd__o311a_2
X_611_ _611_/A1 _603_/Y _608_/X _610_/Y VGND VGND VPWR VPWR _611_/X sky130_fd_sc_hd__a22o_2
X_473_ _648_/Q _647_/Q VGND VGND VPWR VPWR _504_/C sky130_fd_sc_hd__and2_2
XFILLER_6_81 VGND VGND VPWR VPWR sky130_fd_sc_hd__decap_3
XFILLER_26_189 VGND VGND VPWR VPWR sky130_fd_sc_hd__decap_3
XFILLER_25_57 VGND VGND VPWR VPWR sky130_fd_sc_hd__decap_3
XFILLER_1_200 VGND VGND VPWR VPWR sky130_fd_sc_hd__decap_3
XFILLER_9_3 VGND VGND VPWR VPWR sky130_fd_sc_hd__decap_3
XFILLER_17_134 VGND VGND VPWR VPWR sky130_fd_sc_hd__fill_1
XFILLER_17_178 VGND VGND VPWR VPWR sky130_fd_sc_hd__decap_3
X_525_ _533_/B input8/X _529_/B _529_/C VGND VGND VPWR VPWR _525_/X sky130_fd_sc_hd__o22a_2
X_456_ _642_/Q _641_/Q _477_/A _643_/Q VGND VGND VPWR VPWR _458_/B sky130_fd_sc_hd__a31o_2
XTAP_TAPCELL_ROW_27_195 VGND VPWR sky130_fd_sc_hd__tapvpwrvgnd_1
XFILLER_32_126 VGND VGND VPWR VPWR sky130_fd_sc_hd__fill_2
XFILLER_15_90 VGND VGND VPWR VPWR sky130_fd_sc_hd__decap_3
X_387_ _661_/Q _662_/Q _659_/Q VGND VGND VPWR VPWR _389_/C sky130_fd_sc_hd__and3b_2
XFILLER_23_104 VGND VGND VPWR VPWR sky130_fd_sc_hd__decap_3
XFILLER_31_181 VGND VGND VPWR VPWR sky130_fd_sc_hd__decap_3
XFILLER_11_48 VGND VGND VPWR VPWR sky130_fd_sc_hd__decap_3
XFILLER_36_12 VGND VGND VPWR VPWR sky130_fd_sc_hd__decap_3
XFILLER_14_137 VGND VGND VPWR VPWR sky130_fd_sc_hd__decap_3
X_310_ _702_/Q VGND VGND VPWR VPWR _310_/Y sky130_fd_sc_hd__inv_2
XFILLER_36_56 VGND VGND VPWR VPWR sky130_fd_sc_hd__decap_3
XFILLER_28_9 VGND VGND VPWR VPWR sky130_fd_sc_hd__decap_3
XFILLER_37_218 VGND VGND VPWR VPWR sky130_fd_sc_hd__decap_3
XFILLER_37_207 VGND VGND VPWR VPWR sky130_fd_sc_hd__decap_3
XFILLER_13_181 VGND VGND VPWR VPWR sky130_fd_sc_hd__decap_3
X_508_ _507_/B _515_/B _502_/Y _510_/B VGND VGND VPWR VPWR _657_/D sky130_fd_sc_hd__a211oi_2
X_439_ _448_/A _533_/A VGND VGND VPWR VPWR _499_/B sky130_fd_sc_hd__nor2_2
XFILLER_9_152 VGND VGND VPWR VPWR sky130_fd_sc_hd__decap_3
XFILLER_36_240 VGND VGND VPWR VPWR sky130_fd_sc_hd__decap_3
XFILLER_11_107 VGND VGND VPWR VPWR sky130_fd_sc_hd__decap_3
XFILLER_22_47 VGND VGND VPWR VPWR sky130_fd_sc_hd__decap_3
XTAP_TAPCELL_ROW_6_111 VGND VPWR sky130_fd_sc_hd__tapvpwrvgnd_1
XFILLER_19_207 VGND VGND VPWR VPWR sky130_fd_sc_hd__decap_3
XTAP_TAPCELL_ROW_29_202 VGND VPWR sky130_fd_sc_hd__tapvpwrvgnd_1
XTAP_TAPCELL_ROW_12_135 VGND VPWR sky130_fd_sc_hd__tapvpwrvgnd_1
XFILLER_8_38 VGND VGND VPWR VPWR sky130_fd_sc_hd__decap_3
XFILLER_8_27 VGND VGND VPWR VPWR sky130_fd_sc_hd__fill_1
XFILLER_10_162 VGND VGND VPWR VPWR sky130_fd_sc_hd__decap_3
XFILLER_12_91 VGND VGND VPWR VPWR sky130_fd_sc_hd__fill_1
XFILLER_6_177 VGND VGND VPWR VPWR sky130_fd_sc_hd__fill_1
XFILLER_6_144 VGND VGND VPWR VPWR sky130_fd_sc_hd__decap_3
XFILLER_6_100 VGND VGND VPWR VPWR sky130_fd_sc_hd__decap_3
XTAP_TAPCELL_ROW_35_227 VGND VPWR sky130_fd_sc_hd__tapvpwrvgnd_1
XFILLER_17_69 VGND VGND VPWR VPWR sky130_fd_sc_hd__fill_1
XFILLER_24_210 VGND VGND VPWR VPWR sky130_fd_sc_hd__decap_3
XFILLER_33_57 VGND VGND VPWR VPWR sky130_fd_sc_hd__decap_3
XFILLER_3_125 VGND VGND VPWR VPWR sky130_fd_sc_hd__decap_3
XTAP_TAPCELL_ROW_40_252 VGND VPWR sky130_fd_sc_hd__tapvpwrvgnd_1
XFILLER_24_3 VGND VGND VPWR VPWR sky130_fd_sc_hd__decap_3
XFILLER_0_50 VGND VGND VPWR VPWR sky130_fd_sc_hd__decap_3
XFILLER_0_72 VGND VGND VPWR VPWR sky130_fd_sc_hd__decap_3
XFILLER_0_94 VGND VGND VPWR VPWR sky130_fd_sc_hd__decap_3
XFILLER_9_92 VGND VGND VPWR VPWR sky130_fd_sc_hd__decap_3
XFILLER_0_106 VGND VGND VPWR VPWR sky130_fd_sc_hd__decap_3
XFILLER_28_24 VGND VGND VPWR VPWR sky130_fd_sc_hd__decap_3
XFILLER_28_46 VGND VGND VPWR VPWR sky130_fd_sc_hd__decap_3
XFILLER_5_39 VGND VGND VPWR VPWR sky130_fd_sc_hd__decap_3
XFILLER_10_9 VGND VGND VPWR VPWR sky130_fd_sc_hd__decap_3
X_687_ _711_/CLK _687_/D load_slew87/X VGND VGND VPWR VPWR _687_/Q sky130_fd_sc_hd__dfrtp_2
XPHY_EDGE_ROW_7_Right_7 VGND VGND VPWR VPWR sky130_fd_sc_hd__decap_3
XFILLER_38_154 VGND VGND VPWR VPWR sky130_fd_sc_hd__decap_3
XFILLER_30_58 VGND VGND VPWR VPWR sky130_fd_sc_hd__decap_3
XFILLER_30_36 VGND VGND VPWR VPWR sky130_fd_sc_hd__fill_2
XFILLER_29_143 VGND VGND VPWR VPWR sky130_fd_sc_hd__decap_3
X_610_ _614_/B _610_/B VGND VGND VPWR VPWR _610_/Y sky130_fd_sc_hd__nand2_2
XFILLER_39_45 VGND VGND VPWR VPWR sky130_fd_sc_hd__decap_3
XFILLER_39_12 VGND VGND VPWR VPWR sky130_fd_sc_hd__decap_3
XFILLER_29_165 VGND VGND VPWR VPWR sky130_fd_sc_hd__decap_3
X_541_ _314_/Y _529_/B _542_/A1 VGND VGND VPWR VPWR _541_/Y sky130_fd_sc_hd__o21ai_2
X_472_ _472_/A1 _478_/B _469_/Y _458_/A VGND VGND VPWR VPWR _647_/D sky130_fd_sc_hd__o211a_2
XFILLER_35_124 VGND VGND VPWR VPWR sky130_fd_sc_hd__decap_3
XFILLER_25_47 VGND VGND VPWR VPWR sky130_fd_sc_hd__decap_3
XFILLER_1_234 VGND VGND VPWR VPWR sky130_fd_sc_hd__fill_1
XFILLER_17_102 VGND VGND VPWR VPWR sky130_fd_sc_hd__fill_1
XFILLER_17_113 VGND VGND VPWR VPWR sky130_fd_sc_hd__decap_3
XFILLER_2_18 VGND VGND VPWR VPWR sky130_fd_sc_hd__decap_3
XFILLER_2_29 VGND VGND VPWR VPWR sky130_fd_sc_hd__decap_3
X_524_ _529_/C _529_/B VGND VGND VPWR VPWR _533_/C sky130_fd_sc_hd__nor2_2
X_455_ _455_/A1 _452_/A _454_/Y VGND VGND VPWR VPWR _642_/D sky130_fd_sc_hd__a21oi_2
X_386_ _644_/Q _646_/Q _645_/Q _648_/Q VGND VGND VPWR VPWR _386_/X sky130_fd_sc_hd__or4_2
XTAP_TAPCELL_ROW_27_196 VGND VPWR sky130_fd_sc_hd__tapvpwrvgnd_1
XFILLER_32_138 VGND VGND VPWR VPWR sky130_fd_sc_hd__fill_2
XFILLER_40_193 VGND VGND VPWR VPWR sky130_fd_sc_hd__decap_3
XTAP_TAPCELL_ROW_2_94 VGND VPWR sky130_fd_sc_hd__tapvpwrvgnd_1
XFILLER_23_127 VGND VGND VPWR VPWR sky130_fd_sc_hd__decap_3
XFILLER_31_193 VGND VGND VPWR VPWR sky130_fd_sc_hd__decap_3
XFILLER_11_16 VGND VGND VPWR VPWR sky130_fd_sc_hd__decap_3
XFILLER_36_46 VGND VGND VPWR VPWR sky130_fd_sc_hd__fill_2
XFILLER_36_24 VGND VGND VPWR VPWR sky130_fd_sc_hd__decap_3
XFILLER_14_105 VGND VGND VPWR VPWR sky130_fd_sc_hd__decap_3
XFILLER_13_193 VGND VGND VPWR VPWR sky130_fd_sc_hd__decap_3
X_507_ _657_/Q _507_/B _507_/C _507_/D VGND VGND VPWR VPWR _510_/B sky130_fd_sc_hd__and4_2
X_438_ _552_/A _529_/B _436_/X _523_/B VGND VGND VPWR VPWR _636_/D sky130_fd_sc_hd__o211a_2
X_369_ _710_/Q _707_/Q VGND VGND VPWR VPWR _369_/X sky130_fd_sc_hd__and2b_2
XFILLER_9_175 VGND VGND VPWR VPWR sky130_fd_sc_hd__fill_1
XFILLER_9_164 VGND VGND VPWR VPWR sky130_fd_sc_hd__decap_3
XFILLER_9_131 VGND VGND VPWR VPWR sky130_fd_sc_hd__decap_3
XFILLER_9_197 VGND VGND VPWR VPWR sky130_fd_sc_hd__decap_3
XFILLER_22_26 VGND VGND VPWR VPWR sky130_fd_sc_hd__fill_2
XTAP_TAPCELL_ROW_6_112 VGND VPWR sky130_fd_sc_hd__tapvpwrvgnd_1
XFILLER_19_219 VGND VGND VPWR VPWR sky130_fd_sc_hd__decap_3
XTAP_TAPCELL_ROW_29_203 VGND VPWR sky130_fd_sc_hd__tapvpwrvgnd_1
XTAP_TAPCELL_ROW_12_136 VGND VPWR sky130_fd_sc_hd__tapvpwrvgnd_1
XFILLER_10_185 VGND VGND VPWR VPWR sky130_fd_sc_hd__decap_3
XFILLER_6_167 VGND VGND VPWR VPWR sky130_fd_sc_hd__decap_3
XFILLER_40_9 VGND VGND VPWR VPWR sky130_fd_sc_hd__decap_3
XFILLER_19_6 VGND VGND VPWR VPWR sky130_fd_sc_hd__decap_3
XTAP_TAPCELL_ROW_35_228 VGND VPWR sky130_fd_sc_hd__tapvpwrvgnd_1
XFILLER_33_244 VGND VGND VPWR VPWR sky130_fd_sc_hd__fill_1
XFILLER_24_200 VGND VGND VPWR VPWR sky130_fd_sc_hd__fill_1
XFILLER_33_47 VGND VGND VPWR VPWR sky130_fd_sc_hd__fill_1
XFILLER_3_137 VGND VGND VPWR VPWR sky130_fd_sc_hd__decap_3
XFILLER_15_222 VGND VGND VPWR VPWR sky130_fd_sc_hd__fill_2
XTAP_TAPCELL_ROW_40_253 VGND VPWR sky130_fd_sc_hd__tapvpwrvgnd_1
XFILLER_21_214 VGND VGND VPWR VPWR sky130_fd_sc_hd__decap_3
XFILLER_21_225 VGND VGND VPWR VPWR sky130_fd_sc_hd__decap_3
XFILLER_5_18 VGND VGND VPWR VPWR sky130_fd_sc_hd__decap_3
XFILLER_18_91 VGND VGND VPWR VPWR sky130_fd_sc_hd__decap_3
X_686_ _703_/CLK _686_/D load_slew99/X VGND VGND VPWR VPWR _686_/Q sky130_fd_sc_hd__dfrtp_2
XFILLER_14_38 VGND VGND VPWR VPWR sky130_fd_sc_hd__decap_3
XFILLER_39_24 VGND VGND VPWR VPWR sky130_fd_sc_hd__decap_3
XFILLER_30_15 VGND VGND VPWR VPWR sky130_fd_sc_hd__decap_3
XFILLER_29_100 VGND VGND VPWR VPWR sky130_fd_sc_hd__decap_3
XFILLER_29_122 VGND VGND VPWR VPWR sky130_fd_sc_hd__decap_3
XFILLER_29_177 VGND VGND VPWR VPWR sky130_fd_sc_hd__fill_1
X_540_ _540_/A VGND VGND VPWR VPWR _540_/Y sky130_fd_sc_hd__inv_2
XFILLER_39_57 VGND VGND VPWR VPWR sky130_fd_sc_hd__fill_1
X_471_ _506_/A _507_/B _506_/C _504_/B VGND VGND VPWR VPWR _478_/B sky130_fd_sc_hd__and4_2
XFILLER_4_221 VGND VGND VPWR VPWR sky130_fd_sc_hd__decap_3
XFILLER_20_81 VGND VGND VPWR VPWR sky130_fd_sc_hd__decap_3
X_669_ _669_/CLK _669_/D load_slew99/X VGND VGND VPWR VPWR _669_/Q sky130_fd_sc_hd__dfrtp_2
XFILLER_35_158 VGND VGND VPWR VPWR sky130_fd_sc_hd__fill_2
XFILLER_35_136 VGND VGND VPWR VPWR sky130_fd_sc_hd__fill_1
XFILLER_6_50 VGND VGND VPWR VPWR sky130_fd_sc_hd__decap_3
XPHY_EDGE_ROW_38_Left_79 VGND VGND VPWR VPWR sky130_fd_sc_hd__decap_3
XFILLER_17_125 VGND VGND VPWR VPWR sky130_fd_sc_hd__decap_3
XFILLER_17_169 VGND VGND VPWR VPWR sky130_fd_sc_hd__decap_3
X_523_ _523_/A _523_/B VGND VGND VPWR VPWR _663_/D sky130_fd_sc_hd__xnor2_2
XFILLER_15_81 VGND VGND VPWR VPWR sky130_fd_sc_hd__decap_3
X_454_ _455_/A1 _452_/A _458_/A VGND VGND VPWR VPWR _454_/Y sky130_fd_sc_hd__o21ai_2
X_385_ _647_/Q _653_/Q _655_/Q _654_/Q VGND VGND VPWR VPWR _385_/X sky130_fd_sc_hd__or4b_2
XTAP_TAPCELL_ROW_27_197 VGND VPWR sky130_fd_sc_hd__tapvpwrvgnd_1
XTAP_TAPCELL_ROW_2_95 VGND VPWR sky130_fd_sc_hd__tapvpwrvgnd_1
XFILLER_31_91 VGND VGND VPWR VPWR sky130_fd_sc_hd__decap_3
XFILLER_11_39 VGND VGND VPWR VPWR sky130_fd_sc_hd__decap_3
XFILLER_31_172 VGND VGND VPWR VPWR sky130_fd_sc_hd__decap_3
XFILLER_14_117 VGND VGND VPWR VPWR sky130_fd_sc_hd__decap_3
XFILLER_14_128 VGND VGND VPWR VPWR sky130_fd_sc_hd__decap_3
XFILLER_22_150 VGND VGND VPWR VPWR sky130_fd_sc_hd__decap_3
X_506_ _506_/A _506_/B _506_/C _506_/D VGND VGND VPWR VPWR _507_/D sky130_fd_sc_hd__and4_2
XFILLER_13_172 VGND VGND VPWR VPWR sky130_fd_sc_hd__decap_3
X_437_ _437_/A _437_/B _437_/C _437_/D VGND VGND VPWR VPWR _529_/B sky130_fd_sc_hd__or4_2
X_368_ _667_/Q _434_/C _636_/Q VGND VGND VPWR VPWR _435_/B sky130_fd_sc_hd__and3b_2
XFILLER_9_143 VGND VGND VPWR VPWR sky130_fd_sc_hd__decap_3
XFILLER_3_51 VGND VGND VPWR VPWR sky130_fd_sc_hd__decap_3
XFILLER_0_9 VGND VGND VPWR VPWR sky130_fd_sc_hd__decap_3
Xfanout100 input31/X VGND VGND VPWR VPWR fanout98/A sky130_fd_sc_hd__clkdlybuf4s25_1
XTAP_TAPCELL_ROW_6_113 VGND VPWR sky130_fd_sc_hd__tapvpwrvgnd_1
XTAP_TAPCELL_ROW_29_204 VGND VPWR sky130_fd_sc_hd__tapvpwrvgnd_1
XPHY_EDGE_ROW_29_Right_29 VGND VGND VPWR VPWR sky130_fd_sc_hd__decap_3
XFILLER_10_131 VGND VGND VPWR VPWR sky130_fd_sc_hd__decap_3
XTAP_TAPCELL_ROW_12_137 VGND VPWR sky130_fd_sc_hd__tapvpwrvgnd_1
XPHY_EDGE_ROW_38_Right_38 VGND VGND VPWR VPWR sky130_fd_sc_hd__decap_3
XFILLER_8_29 VGND VGND VPWR VPWR sky130_fd_sc_hd__decap_3
XFILLER_8_18 VGND VGND VPWR VPWR sky130_fd_sc_hd__decap_3
XFILLER_6_135 VGND VGND VPWR VPWR sky130_fd_sc_hd__fill_2
XFILLER_10_197 VGND VGND VPWR VPWR sky130_fd_sc_hd__decap_3
XFILLER_12_71 VGND VGND VPWR VPWR sky130_fd_sc_hd__decap_3
XFILLER_33_9 VGND VGND VPWR VPWR sky130_fd_sc_hd__decap_3
XPHY_EDGE_ROW_25_Left_66 VGND VGND VPWR VPWR sky130_fd_sc_hd__decap_3
XTAP_TAPCELL_ROW_35_229 VGND VPWR sky130_fd_sc_hd__tapvpwrvgnd_1
XFILLER_5_190 VGND VGND VPWR VPWR sky130_fd_sc_hd__decap_3
XFILLER_33_15 VGND VGND VPWR VPWR sky130_fd_sc_hd__decap_3
XFILLER_3_149 VGND VGND VPWR VPWR sky130_fd_sc_hd__decap_3
XFILLER_15_234 VGND VGND VPWR VPWR sky130_fd_sc_hd__decap_3
XFILLER_31_6 VGND VGND VPWR VPWR sky130_fd_sc_hd__decap_3
XFILLER_0_41 VGND VGND VPWR VPWR sky130_fd_sc_hd__decap_3
XFILLER_0_63 VGND VGND VPWR VPWR sky130_fd_sc_hd__decap_3
XFILLER_0_85 VGND VGND VPWR VPWR sky130_fd_sc_hd__decap_3
XTAP_TAPCELL_ROW_31_210 VGND VPWR sky130_fd_sc_hd__tapvpwrvgnd_1
XFILLER_9_83 VGND VGND VPWR VPWR sky130_fd_sc_hd__decap_3
XFILLER_0_119 VGND VGND VPWR VPWR sky130_fd_sc_hd__decap_3
XFILLER_28_15 VGND VGND VPWR VPWR sky130_fd_sc_hd__decap_3
XFILLER_18_81 VGND VGND VPWR VPWR sky130_fd_sc_hd__decap_3
X_685_ _703_/CLK _685_/D load_slew99/X VGND VGND VPWR VPWR _685_/Q sky130_fd_sc_hd__dfrtp_2
XFILLER_34_91 VGND VGND VPWR VPWR sky130_fd_sc_hd__decap_3
Xload_slew80 _518_/B1 VGND VGND VPWR VPWR _604_/A sky130_fd_sc_hd__clkbuf_4
XPHY_EDGE_ROW_12_Left_53 VGND VGND VPWR VPWR sky130_fd_sc_hd__decap_3
XFILLER_30_27 VGND VGND VPWR VPWR sky130_fd_sc_hd__fill_1
XFILLER_30_49 VGND VGND VPWR VPWR sky130_fd_sc_hd__decap_3
XFILLER_29_134 VGND VGND VPWR VPWR sky130_fd_sc_hd__decap_3
X_470_ _646_/Q _645_/Q VGND VGND VPWR VPWR _504_/B sky130_fd_sc_hd__and2_2
XFILLER_20_60 VGND VGND VPWR VPWR sky130_fd_sc_hd__decap_3
XFILLER_20_93 VGND VGND VPWR VPWR sky130_fd_sc_hd__decap_3
XFILLER_29_91 VGND VGND VPWR VPWR sky130_fd_sc_hd__decap_3
X_599_ _604_/A _680_/Q VGND VGND VPWR VPWR _599_/Y sky130_fd_sc_hd__nor2_2
X_668_ _670_/CLK _668_/D fanout96/X VGND VGND VPWR VPWR _668_/Q sky130_fd_sc_hd__dfrtp_2
XFILLER_6_62 VGND VGND VPWR VPWR sky130_fd_sc_hd__decap_3
XFILLER_34_192 VGND VGND VPWR VPWR sky130_fd_sc_hd__decap_3
XFILLER_1_225 VGND VGND VPWR VPWR sky130_fd_sc_hd__decap_3
XFILLER_9_6 VGND VGND VPWR VPWR sky130_fd_sc_hd__decap_3
X_522_ _522_/A _522_/B _522_/C VGND VGND VPWR VPWR _662_/D sky130_fd_sc_hd__and3_2
X_453_ _453_/A1 _477_/A _452_/Y _458_/A VGND VGND VPWR VPWR _641_/D sky130_fd_sc_hd__o211a_2
XFILLER_15_60 VGND VGND VPWR VPWR sky130_fd_sc_hd__decap_3
XFILLER_15_93 VGND VGND VPWR VPWR sky130_fd_sc_hd__decap_3
X_384_ _506_/A _506_/B _457_/A VGND VGND VPWR VPWR _384_/X sky130_fd_sc_hd__and3_2
XTAP_TAPCELL_ROW_2_96 VGND VPWR sky130_fd_sc_hd__tapvpwrvgnd_1
XFILLER_23_107 VGND VGND VPWR VPWR sky130_fd_sc_hd__decap_3
XFILLER_31_184 VGND VGND VPWR VPWR sky130_fd_sc_hd__decap_3
XFILLER_36_15 VGND VGND VPWR VPWR sky130_fd_sc_hd__decap_3
XFILLER_22_162 VGND VGND VPWR VPWR sky130_fd_sc_hd__decap_3
XFILLER_22_184 VGND VGND VPWR VPWR sky130_fd_sc_hd__decap_3
XTAP_TAPCELL_ROW_9_122 VGND VPWR sky130_fd_sc_hd__tapvpwrvgnd_1
XFILLER_7_3 VGND VGND VPWR VPWR sky130_fd_sc_hd__decap_3
X_505_ _653_/Q _654_/Q _655_/Q _656_/Q VGND VGND VPWR VPWR _507_/C sky130_fd_sc_hd__and4_2
X_436_ _532_/S _435_/X _636_/Q VGND VGND VPWR VPWR _436_/X sky130_fd_sc_hd__a21o_2
XTAP_TAPCELL_ROW_15_146 VGND VPWR sky130_fd_sc_hd__tapvpwrvgnd_1
XFILLER_13_162 VGND VGND VPWR VPWR sky130_fd_sc_hd__decap_3
XFILLER_13_184 VGND VGND VPWR VPWR sky130_fd_sc_hd__decap_3
X_367_ _665_/Q _666_/Q _664_/Q VGND VGND VPWR VPWR _434_/C sky130_fd_sc_hd__nor3b_2
XFILLER_9_155 VGND VGND VPWR VPWR sky130_fd_sc_hd__decap_3
XFILLER_3_30 VGND VGND VPWR VPWR sky130_fd_sc_hd__decap_3
XTAP_TAPCELL_ROW_38_238 VGND VPWR sky130_fd_sc_hd__tapvpwrvgnd_1
XFILLER_36_243 VGND VGND VPWR VPWR sky130_fd_sc_hd__fill_2
Xfanout101 _421_/A VGND VGND VPWR VPWR _448_/A sky130_fd_sc_hd__clkdlybuf4s25_1
XTAP_TAPCELL_ROW_29_205 VGND VPWR sky130_fd_sc_hd__tapvpwrvgnd_1
XFILLER_27_221 VGND VGND VPWR VPWR sky130_fd_sc_hd__decap_3
XFILLER_6_158 VGND VGND VPWR VPWR sky130_fd_sc_hd__decap_3
XFILLER_6_147 VGND VGND VPWR VPWR sky130_fd_sc_hd__decap_3
XPHY_EDGE_ROW_0_Left_41 VGND VGND VPWR VPWR sky130_fd_sc_hd__decap_3
XFILLER_33_202 VGND VGND VPWR VPWR sky130_fd_sc_hd__decap_3
X_419_ _698_/Q _697_/Q _419_/C _419_/D VGND VGND VPWR VPWR _421_/B sky130_fd_sc_hd__and4_2
XFILLER_5_180 VGND VGND VPWR VPWR sky130_fd_sc_hd__decap_3
XFILLER_24_213 VGND VGND VPWR VPWR sky130_fd_sc_hd__decap_3
XFILLER_3_128 VGND VGND VPWR VPWR sky130_fd_sc_hd__decap_3
XFILLER_23_93 VGND VGND VPWR VPWR sky130_fd_sc_hd__decap_3
XFILLER_24_6 VGND VGND VPWR VPWR sky130_fd_sc_hd__fill_1
XFILLER_0_53 VGND VGND VPWR VPWR sky130_fd_sc_hd__decap_3
XFILLER_0_75 VGND VGND VPWR VPWR sky130_fd_sc_hd__decap_3
XFILLER_0_97 VGND VGND VPWR VPWR sky130_fd_sc_hd__decap_3
XTAP_TAPCELL_ROW_31_211 VGND VPWR sky130_fd_sc_hd__tapvpwrvgnd_1
XFILLER_9_95 VGND VGND VPWR VPWR sky130_fd_sc_hd__decap_3
XFILLER_0_109 VGND VGND VPWR VPWR sky130_fd_sc_hd__decap_3
XFILLER_28_27 VGND VGND VPWR VPWR sky130_fd_sc_hd__fill_1
XFILLER_28_49 VGND VGND VPWR VPWR sky130_fd_sc_hd__decap_3
Xclkbuf_4_15_0_clk clkbuf_0_clk/X VGND VGND VPWR VPWR _677_/CLK sky130_fd_sc_hd__clkbuf_8
X_684_ _684_/CLK _684_/D load_slew99/X VGND VGND VPWR VPWR _684_/Q sky130_fd_sc_hd__dfrtp_2
XFILLER_22_3 VGND VGND VPWR VPWR sky130_fd_sc_hd__decap_3
XFILLER_38_157 VGND VGND VPWR VPWR sky130_fd_sc_hd__decap_3
Xload_slew92 fanout91/X VGND VGND VPWR VPWR load_slew92/X sky130_fd_sc_hd__clkbuf_4
XFILLER_39_48 VGND VGND VPWR VPWR sky130_fd_sc_hd__decap_3
XFILLER_39_15 VGND VGND VPWR VPWR sky130_fd_sc_hd__decap_3
XFILLER_29_113 VGND VGND VPWR VPWR sky130_fd_sc_hd__decap_3
XFILLER_29_146 VGND VGND VPWR VPWR sky130_fd_sc_hd__fill_2
XFILLER_20_72 VGND VGND VPWR VPWR sky130_fd_sc_hd__decap_3
XFILLER_4_212 VGND VGND VPWR VPWR sky130_fd_sc_hd__decap_3
X_598_ _598_/A _598_/B VGND VGND VPWR VPWR _679_/D sky130_fd_sc_hd__nor2_2
X_667_ _667_/CLK _667_/D fanout95/X VGND VGND VPWR VPWR _667_/Q sky130_fd_sc_hd__dfrtp_2
XFILLER_35_127 VGND VGND VPWR VPWR sky130_fd_sc_hd__decap_3
XFILLER_6_41 VGND VGND VPWR VPWR sky130_fd_sc_hd__decap_3
XFILLER_19_190 VGND VGND VPWR VPWR sky130_fd_sc_hd__decap_3
XFILLER_26_127 VGND VGND VPWR VPWR sky130_fd_sc_hd__decap_3
XFILLER_25_39 VGND VGND VPWR VPWR sky130_fd_sc_hd__fill_2
XFILLER_17_116 VGND VGND VPWR VPWR sky130_fd_sc_hd__decap_3
X_521_ _660_/Q _661_/Q _662_/Q _521_/D VGND VGND VPWR VPWR _522_/C sky130_fd_sc_hd__nand4_2
X_452_ _452_/A VGND VGND VPWR VPWR _452_/Y sky130_fd_sc_hd__inv_2
X_383_ _642_/Q _641_/Q _643_/Q VGND VGND VPWR VPWR _457_/A sky130_fd_sc_hd__and3_2
XFILLER_15_72 VGND VGND VPWR VPWR sky130_fd_sc_hd__decap_3
XFILLER_40_130 VGND VGND VPWR VPWR sky130_fd_sc_hd__fill_2
XFILLER_31_60 VGND VGND VPWR VPWR sky130_fd_sc_hd__fill_1
Xoutput60 _679_/Q VGND VGND VPWR VPWR sec_tens_o[3] sky130_fd_sc_hd__clkdlybuf4s25_1
XTAP_TAPCELL_ROW_2_97 VGND VPWR sky130_fd_sc_hd__tapvpwrvgnd_1
XFILLER_31_82 VGND VGND VPWR VPWR sky130_fd_sc_hd__decap_3
XFILLER_16_171 VGND VGND VPWR VPWR sky130_fd_sc_hd__fill_2
XFILLER_31_152 VGND VGND VPWR VPWR sky130_fd_sc_hd__decap_3
XFILLER_11_19 VGND VGND VPWR VPWR sky130_fd_sc_hd__decap_3
XFILLER_31_196 VGND VGND VPWR VPWR sky130_fd_sc_hd__fill_1
XFILLER_14_108 VGND VGND VPWR VPWR sky130_fd_sc_hd__decap_3
XFILLER_36_27 VGND VGND VPWR VPWR sky130_fd_sc_hd__fill_1
XFILLER_22_141 VGND VGND VPWR VPWR sky130_fd_sc_hd__decap_3
XFILLER_22_174 VGND VGND VPWR VPWR sky130_fd_sc_hd__decap_3
XTAP_TAPCELL_ROW_9_123 VGND VPWR sky130_fd_sc_hd__tapvpwrvgnd_1
X_504_ _506_/B _504_/B _504_/C _504_/D VGND VGND VPWR VPWR _512_/D sky130_fd_sc_hd__and4_2
X_435_ _533_/A _435_/B _435_/C VGND VGND VPWR VPWR _435_/X sky130_fd_sc_hd__or3_2
X_366_ _355_/X _361_/Y _364_/A VGND VGND VPWR VPWR _629_/D sky130_fd_sc_hd__a21oi_2
XTAP_TAPCELL_ROW_15_147 VGND VPWR sky130_fd_sc_hd__tapvpwrvgnd_1
XFILLER_9_134 VGND VGND VPWR VPWR sky130_fd_sc_hd__decap_3
XFILLER_9_101 VGND VGND VPWR VPWR sky130_fd_sc_hd__decap_3
XTAP_TAPCELL_ROW_23_180 VGND VPWR sky130_fd_sc_hd__tapvpwrvgnd_1
XFILLER_9_167 VGND VGND VPWR VPWR sky130_fd_sc_hd__fill_1
XFILLER_3_42 VGND VGND VPWR VPWR sky130_fd_sc_hd__decap_3
XTAP_TAPCELL_ROW_38_239 VGND VPWR sky130_fd_sc_hd__tapvpwrvgnd_1
XFILLER_36_200 VGND VGND VPWR VPWR sky130_fd_sc_hd__fill_1
XFILLER_22_29 VGND VGND VPWR VPWR sky130_fd_sc_hd__decap_3
Xfanout102 input2/X VGND VGND VPWR VPWR _421_/A sky130_fd_sc_hd__clkdlybuf4s25_1
XFILLER_10_188 VGND VGND VPWR VPWR sky130_fd_sc_hd__decap_3
XFILLER_12_40 VGND VGND VPWR VPWR sky130_fd_sc_hd__decap_3
XFILLER_18_200 VGND VGND VPWR VPWR sky130_fd_sc_hd__decap_3
XFILLER_19_9 VGND VGND VPWR VPWR sky130_fd_sc_hd__decap_3
X_418_ _421_/A _418_/B _420_/B VGND VGND VPWR VPWR _697_/D sky130_fd_sc_hd__nor3_2
X_349_ _672_/Q _333_/Y _631_/D _676_/Q VGND VGND VPWR VPWR _349_/X sky130_fd_sc_hd__a22o_2
XFILLER_15_214 VGND VGND VPWR VPWR sky130_fd_sc_hd__fill_1
XFILLER_15_225 VGND VGND VPWR VPWR sky130_fd_sc_hd__decap_3
XFILLER_0_21 VGND VGND VPWR VPWR sky130_fd_sc_hd__decap_3
XFILLER_0_32 VGND VGND VPWR VPWR sky130_fd_sc_hd__decap_3
XFILLER_21_228 VGND VGND VPWR VPWR sky130_fd_sc_hd__fill_1
XTAP_TAPCELL_ROW_31_212 VGND VPWR sky130_fd_sc_hd__tapvpwrvgnd_1
XFILLER_9_41 VGND VGND VPWR VPWR sky130_fd_sc_hd__decap_3
XFILLER_18_94 VGND VGND VPWR VPWR sky130_fd_sc_hd__fill_1
X_683_ _709_/CLK _683_/D load_slew99/X VGND VGND VPWR VPWR _683_/Q sky130_fd_sc_hd__dfrtp_2
XFILLER_15_3 VGND VGND VPWR VPWR sky130_fd_sc_hd__decap_3
XFILLER_30_18 VGND VGND VPWR VPWR sky130_fd_sc_hd__decap_3
XFILLER_29_103 VGND VGND VPWR VPWR sky130_fd_sc_hd__decap_3
XFILLER_29_125 VGND VGND VPWR VPWR sky130_fd_sc_hd__decap_3
XFILLER_39_27 VGND VGND VPWR VPWR sky130_fd_sc_hd__decap_3
XFILLER_20_51 VGND VGND VPWR VPWR sky130_fd_sc_hd__decap_3
XFILLER_29_60 VGND VGND VPWR VPWR sky130_fd_sc_hd__decap_3
XFILLER_29_82 VGND VGND VPWR VPWR sky130_fd_sc_hd__decap_3
X_597_ _679_/Q _585_/A _593_/B _564_/A VGND VGND VPWR VPWR _598_/B sky130_fd_sc_hd__a31o_2
X_666_ _667_/CLK _666_/D _628_/SET_B VGND VGND VPWR VPWR _666_/Q sky130_fd_sc_hd__dfrtp_2
Xclkbuf_4_14_0_clk clkbuf_0_clk/X VGND VGND VPWR VPWR _709_/CLK sky130_fd_sc_hd__clkbuf_8
XFILLER_6_53 VGND VGND VPWR VPWR sky130_fd_sc_hd__decap_3
XFILLER_34_150 VGND VGND VPWR VPWR sky130_fd_sc_hd__fill_2
X_520_ _660_/Q _661_/Q _521_/D _662_/Q VGND VGND VPWR VPWR _522_/B sky130_fd_sc_hd__a31o_2
XFILLER_15_84 VGND VGND VPWR VPWR sky130_fd_sc_hd__decap_3
XFILLER_17_128 VGND VGND VPWR VPWR sky130_fd_sc_hd__decap_3
XFILLER_25_150 VGND VGND VPWR VPWR sky130_fd_sc_hd__decap_3
XFILLER_25_172 VGND VGND VPWR VPWR sky130_fd_sc_hd__decap_3
X_451_ _465_/A _641_/Q _506_/A VGND VGND VPWR VPWR _452_/A sky130_fd_sc_hd__and3_2
X_382_ _650_/Q _649_/Q _652_/Q _651_/Q VGND VGND VPWR VPWR _506_/B sky130_fd_sc_hd__and4_2
XFILLER_31_94 VGND VGND VPWR VPWR sky130_fd_sc_hd__decap_3
Xoutput61 _623_/Q VGND VGND VPWR VPWR seg_o[0] sky130_fd_sc_hd__clkdlybuf4s25_1
Xoutput50 _670_/Q VGND VGND VPWR VPWR min_tens_o[2] sky130_fd_sc_hd__clkdlybuf4s25_1
X_649_ _653_/CLK _649_/D load_slew85/X VGND VGND VPWR VPWR _649_/Q sky130_fd_sc_hd__dfrtp_2
XFILLER_31_175 VGND VGND VPWR VPWR sky130_fd_sc_hd__decap_3
XFILLER_39_231 VGND VGND VPWR VPWR sky130_fd_sc_hd__decap_3
XFILLER_22_153 VGND VGND VPWR VPWR sky130_fd_sc_hd__decap_3
XTAP_TAPCELL_ROW_9_124 VGND VPWR sky130_fd_sc_hd__tapvpwrvgnd_1
XFILLER_26_50 VGND VGND VPWR VPWR sky130_fd_sc_hd__decap_3
X_503_ _654_/Q _655_/Q _656_/Q _657_/Q VGND VGND VPWR VPWR _504_/D sky130_fd_sc_hd__and4_2
XFILLER_13_175 VGND VGND VPWR VPWR sky130_fd_sc_hd__decap_3
X_434_ _636_/Q _667_/Q _434_/C VGND VGND VPWR VPWR _435_/C sky130_fd_sc_hd__and3b_2
X_365_ _353_/B _355_/X _364_/A VGND VGND VPWR VPWR _628_/D sky130_fd_sc_hd__a21oi_2
XTAP_TAPCELL_ROW_23_181 VGND VPWR sky130_fd_sc_hd__tapvpwrvgnd_1
XTAP_TAPCELL_ROW_15_148 VGND VPWR sky130_fd_sc_hd__tapvpwrvgnd_1
XFILLER_9_146 VGND VGND VPWR VPWR sky130_fd_sc_hd__decap_3
XFILLER_9_113 VGND VGND VPWR VPWR sky130_fd_sc_hd__decap_3
XFILLER_3_54 VGND VGND VPWR VPWR sky130_fd_sc_hd__fill_2
XFILLER_3_21 VGND VGND VPWR VPWR sky130_fd_sc_hd__decap_3
XFILLER_27_212 VGND VGND VPWR VPWR sky130_fd_sc_hd__decap_3
XFILLER_10_112 VGND VGND VPWR VPWR sky130_fd_sc_hd__decap_3
XFILLER_10_134 VGND VGND VPWR VPWR sky130_fd_sc_hd__decap_3
XFILLER_12_74 VGND VGND VPWR VPWR sky130_fd_sc_hd__fill_2
XPHY_EDGE_ROW_16_Right_16 VGND VGND VPWR VPWR sky130_fd_sc_hd__decap_3
X_417_ _697_/Q _419_/C _419_/D VGND VGND VPWR VPWR _420_/B sky130_fd_sc_hd__and3_2
X_348_ _685_/Q _684_/Q _636_/Q _686_/Q VGND VGND VPWR VPWR _348_/X sky130_fd_sc_hd__and4b_2
XPHY_EDGE_ROW_25_Right_25 VGND VGND VPWR VPWR sky130_fd_sc_hd__decap_3
XFILLER_5_193 VGND VGND VPWR VPWR sky130_fd_sc_hd__decap_3
XPHY_EDGE_ROW_34_Right_34 VGND VGND VPWR VPWR sky130_fd_sc_hd__decap_3
XFILLER_33_18 VGND VGND VPWR VPWR sky130_fd_sc_hd__fill_2
XFILLER_3_119 VGND VGND VPWR VPWR sky130_fd_sc_hd__decap_3
XTAP_TAPCELL_ROW_40_246 VGND VPWR sky130_fd_sc_hd__tapvpwrvgnd_1
XFILLER_2_141 VGND VGND VPWR VPWR sky130_fd_sc_hd__decap_3
XFILLER_31_9 VGND VGND VPWR VPWR sky130_fd_sc_hd__decap_3
XFILLER_0_44 VGND VGND VPWR VPWR sky130_fd_sc_hd__decap_3
XFILLER_0_66 VGND VGND VPWR VPWR sky130_fd_sc_hd__decap_3
XFILLER_0_88 VGND VGND VPWR VPWR sky130_fd_sc_hd__decap_3
XTAP_TAPCELL_ROW_31_213 VGND VPWR sky130_fd_sc_hd__tapvpwrvgnd_1
XFILLER_9_86 VGND VGND VPWR VPWR sky130_fd_sc_hd__decap_3
XFILLER_28_18 VGND VGND VPWR VPWR sky130_fd_sc_hd__decap_3
XFILLER_28_29 VGND VGND VPWR VPWR sky130_fd_sc_hd__decap_3
X_682_ _709_/CLK _682_/D load_slew89/X VGND VGND VPWR VPWR _682_/Q sky130_fd_sc_hd__dfrtp_2
XFILLER_7_222 VGND VGND VPWR VPWR sky130_fd_sc_hd__fill_2
XFILLER_34_94 VGND VGND VPWR VPWR sky130_fd_sc_hd__decap_3
XFILLER_34_83 VGND VGND VPWR VPWR sky130_fd_sc_hd__fill_1
Xload_slew83 fanout82/X VGND VGND VPWR VPWR load_slew83/X sky130_fd_sc_hd__clkbuf_4
XFILLER_38_104 VGND VGND VPWR VPWR sky130_fd_sc_hd__fill_2
Xload_slew94 fanout93/X VGND VGND VPWR VPWR _628_/SET_B sky130_fd_sc_hd__buf_2
XFILLER_29_137 VGND VGND VPWR VPWR sky130_fd_sc_hd__decap_3
XPHY_EDGE_ROW_2_Right_2 VGND VGND VPWR VPWR sky130_fd_sc_hd__decap_3
XFILLER_20_63 VGND VGND VPWR VPWR sky130_fd_sc_hd__decap_3
XFILLER_20_96 VGND VGND VPWR VPWR sky130_fd_sc_hd__decap_3
XFILLER_28_181 VGND VGND VPWR VPWR sky130_fd_sc_hd__decap_3
XFILLER_29_94 VGND VGND VPWR VPWR sky130_fd_sc_hd__decap_3
X_665_ _665_/CLK _665_/D fanout93/X VGND VGND VPWR VPWR _665_/Q sky130_fd_sc_hd__dfrtp_2
XFILLER_35_118 VGND VGND VPWR VPWR sky130_fd_sc_hd__decap_3
X_596_ _585_/A _593_/B _596_/B1 VGND VGND VPWR VPWR _598_/A sky130_fd_sc_hd__a21oi_2
XFILLER_6_65 VGND VGND VPWR VPWR sky130_fd_sc_hd__decap_3
XFILLER_6_32 VGND VGND VPWR VPWR sky130_fd_sc_hd__decap_3
XFILLER_6_21 VGND VGND VPWR VPWR sky130_fd_sc_hd__decap_3
XPHY_EDGE_ROW_16_Left_57 VGND VGND VPWR VPWR sky130_fd_sc_hd__decap_3
XFILLER_19_181 VGND VGND VPWR VPWR sky130_fd_sc_hd__decap_3
XFILLER_34_195 VGND VGND VPWR VPWR sky130_fd_sc_hd__fill_1
XFILLER_1_228 VGND VGND VPWR VPWR sky130_fd_sc_hd__decap_3
XFILLER_9_9 VGND VGND VPWR VPWR sky130_fd_sc_hd__decap_3
XFILLER_15_52 VGND VGND VPWR VPWR sky130_fd_sc_hd__decap_3
XFILLER_15_63 VGND VGND VPWR VPWR sky130_fd_sc_hd__decap_3
XFILLER_15_96 VGND VGND VPWR VPWR sky130_fd_sc_hd__decap_3
XFILLER_25_184 VGND VGND VPWR VPWR sky130_fd_sc_hd__decap_3
X_450_ _477_/A _458_/A _450_/C VGND VGND VPWR VPWR _640_/D sky130_fd_sc_hd__and3b_2
X_381_ _637_/Q _638_/Q _640_/Q _639_/Q VGND VGND VPWR VPWR _506_/A sky130_fd_sc_hd__and4_2
XFILLER_40_165 VGND VGND VPWR VPWR sky130_fd_sc_hd__decap_3
XFILLER_31_51 VGND VGND VPWR VPWR sky130_fd_sc_hd__decap_3
Xoutput62 _624_/Q VGND VGND VPWR VPWR seg_o[1] sky130_fd_sc_hd__clkdlybuf4s25_1
Xoutput51 _671_/Q VGND VGND VPWR VPWR min_tens_o[3] sky130_fd_sc_hd__clkdlybuf4s25_1
Xoutput40 _665_/Q VGND VGND VPWR VPWR hour_ones_o[1] sky130_fd_sc_hd__clkdlybuf4s25_1
X_648_ _653_/CLK _648_/D fanout82/X VGND VGND VPWR VPWR _648_/Q sky130_fd_sc_hd__dfrtp_2
XFILLER_16_195 VGND VGND VPWR VPWR sky130_fd_sc_hd__fill_1
X_579_ _574_/C _675_/Q _575_/X _564_/Y VGND VGND VPWR VPWR _579_/Y sky130_fd_sc_hd__o31ai_2
XTAP_TAPCELL_ROW_26_190 VGND VPWR sky130_fd_sc_hd__tapvpwrvgnd_1
XFILLER_31_187 VGND VGND VPWR VPWR sky130_fd_sc_hd__decap_3
XFILLER_39_210 VGND VGND VPWR VPWR sky130_fd_sc_hd__decap_3
XFILLER_36_18 VGND VGND VPWR VPWR sky130_fd_sc_hd__decap_3
XFILLER_22_187 VGND VGND VPWR VPWR sky130_fd_sc_hd__fill_1
Xclkbuf_4_13_0_clk clkbuf_0_clk/X VGND VGND VPWR VPWR _675_/CLK sky130_fd_sc_hd__clkbuf_8
XTAP_TAPCELL_ROW_9_125 VGND VPWR sky130_fd_sc_hd__tapvpwrvgnd_1
XFILLER_7_6 VGND VGND VPWR VPWR sky130_fd_sc_hd__decap_3
X_502_ _502_/A1 _498_/X _502_/B1 VGND VGND VPWR VPWR _502_/Y sky130_fd_sc_hd__a21oi_2
X_433_ _372_/X _376_/X _533_/A _369_/X VGND VGND VPWR VPWR _532_/S sky130_fd_sc_hd__a211o_2
XFILLER_13_110 VGND VGND VPWR VPWR sky130_fd_sc_hd__fill_2
XFILLER_13_132 VGND VGND VPWR VPWR sky130_fd_sc_hd__decap_3
XFILLER_13_165 VGND VGND VPWR VPWR sky130_fd_sc_hd__decap_3
XFILLER_13_187 VGND VGND VPWR VPWR sky130_fd_sc_hd__decap_3
X_364_ _364_/A _364_/B VGND VGND VPWR VPWR _627_/D sky130_fd_sc_hd__nor2_2
XTAP_TAPCELL_ROW_15_149 VGND VPWR sky130_fd_sc_hd__tapvpwrvgnd_1
XFILLER_9_169 VGND VGND VPWR VPWR sky130_fd_sc_hd__decap_3
XFILLER_9_158 VGND VGND VPWR VPWR sky130_fd_sc_hd__decap_3
XFILLER_3_33 VGND VGND VPWR VPWR sky130_fd_sc_hd__decap_3
XPHY_EDGE_ROW_19_Left_60 VGND VGND VPWR VPWR sky130_fd_sc_hd__decap_3
XFILLER_5_3 VGND VGND VPWR VPWR sky130_fd_sc_hd__decap_3
X_416_ _419_/C _419_/D _416_/B1 VGND VGND VPWR VPWR _418_/B sky130_fd_sc_hd__a21oi_2
XFILLER_37_94 VGND VGND VPWR VPWR sky130_fd_sc_hd__decap_3
XFILLER_33_205 VGND VGND VPWR VPWR sky130_fd_sc_hd__decap_3
X_347_ _685_/Q _684_/Q _686_/Q VGND VGND VPWR VPWR _635_/D sky130_fd_sc_hd__and3b_2
XTAP_TAPCELL_ROW_11_130 VGND VPWR sky130_fd_sc_hd__tapvpwrvgnd_1
XFILLER_5_183 VGND VGND VPWR VPWR sky130_fd_sc_hd__fill_1
XTAP_TAPCELL_ROW_34_222 VGND VPWR sky130_fd_sc_hd__tapvpwrvgnd_1
XPHY_EDGE_ROW_4_Left_45 VGND VGND VPWR VPWR sky130_fd_sc_hd__decap_3
XFILLER_23_96 VGND VGND VPWR VPWR sky130_fd_sc_hd__decap_3
XTAP_TAPCELL_ROW_40_247 VGND VPWR sky130_fd_sc_hd__tapvpwrvgnd_1
XFILLER_2_131 VGND VGND VPWR VPWR sky130_fd_sc_hd__decap_3
XFILLER_2_186 VGND VGND VPWR VPWR sky130_fd_sc_hd__fill_2
XFILLER_2_197 VGND VGND VPWR VPWR sky130_fd_sc_hd__decap_3
XFILLER_0_12 VGND VGND VPWR VPWR sky130_fd_sc_hd__decap_3
XFILLER_0_78 VGND VGND VPWR VPWR sky130_fd_sc_hd__decap_3
XFILLER_9_98 VGND VGND VPWR VPWR sky130_fd_sc_hd__decap_3
X_681_ _703_/CLK _681_/D load_slew99/X VGND VGND VPWR VPWR _681_/Q sky130_fd_sc_hd__dfrtp_2
XFILLER_22_6 VGND VGND VPWR VPWR sky130_fd_sc_hd__fill_1
XFILLER_38_127 VGND VGND VPWR VPWR sky130_fd_sc_hd__decap_3
XFILLER_38_138 VGND VGND VPWR VPWR sky130_fd_sc_hd__fill_2
XFILLER_39_18 VGND VGND VPWR VPWR sky130_fd_sc_hd__decap_3
XFILLER_29_116 VGND VGND VPWR VPWR sky130_fd_sc_hd__decap_3
XFILLER_37_193 VGND VGND VPWR VPWR sky130_fd_sc_hd__decap_3
XFILLER_20_42 VGND VGND VPWR VPWR sky130_fd_sc_hd__decap_3
XFILLER_4_215 VGND VGND VPWR VPWR sky130_fd_sc_hd__decap_3
XFILLER_20_75 VGND VGND VPWR VPWR sky130_fd_sc_hd__decap_3
XFILLER_28_160 VGND VGND VPWR VPWR sky130_fd_sc_hd__decap_3
XFILLER_28_193 VGND VGND VPWR VPWR sky130_fd_sc_hd__decap_3
X_595_ _585_/A _594_/Y _591_/Y VGND VGND VPWR VPWR _678_/D sky130_fd_sc_hd__a21oi_2
X_664_ _665_/CLK _664_/D fanout93/X VGND VGND VPWR VPWR _664_/Q sky130_fd_sc_hd__dfrtp_2
XFILLER_6_44 VGND VGND VPWR VPWR sky130_fd_sc_hd__decap_3
XFILLER_20_3 VGND VGND VPWR VPWR sky130_fd_sc_hd__fill_1
XFILLER_19_193 VGND VGND VPWR VPWR sky130_fd_sc_hd__decap_3
XFILLER_34_174 VGND VGND VPWR VPWR sky130_fd_sc_hd__decap_3
XFILLER_34_141 VGND VGND VPWR VPWR sky130_fd_sc_hd__decap_3
XFILLER_17_119 VGND VGND VPWR VPWR sky130_fd_sc_hd__decap_3
XFILLER_15_42 VGND VGND VPWR VPWR sky130_fd_sc_hd__decap_3
XFILLER_15_75 VGND VGND VPWR VPWR sky130_fd_sc_hd__decap_3
X_380_ _686_/Q _685_/Q _328_/Y VGND VGND VPWR VPWR _630_/D sky130_fd_sc_hd__a21o_2
Xoutput52 _622_/Q VGND VGND VPWR VPWR rollover_pulse_o sky130_fd_sc_hd__clkdlybuf4s25_1
Xoutput41 _666_/Q VGND VGND VPWR VPWR hour_ones_o[2] sky130_fd_sc_hd__clkdlybuf4s25_1
XPHY_EDGE_ROW_33_Left_74 VGND VGND VPWR VPWR sky130_fd_sc_hd__decap_3
XFILLER_31_85 VGND VGND VPWR VPWR sky130_fd_sc_hd__decap_3
XFILLER_31_30 VGND VGND VPWR VPWR sky130_fd_sc_hd__decap_3
Xoutput63 _625_/Q VGND VGND VPWR VPWR seg_o[2] sky130_fd_sc_hd__clkdlybuf4s25_1
XFILLER_16_141 VGND VGND VPWR VPWR sky130_fd_sc_hd__decap_3
X_578_ _578_/A1 _573_/S _577_/X VGND VGND VPWR VPWR _674_/D sky130_fd_sc_hd__o21a_2
X_647_ _653_/CLK _647_/D load_slew85/X VGND VGND VPWR VPWR _647_/Q sky130_fd_sc_hd__dfrtp_2
XTAP_TAPCELL_ROW_18_158 VGND VPWR sky130_fd_sc_hd__tapvpwrvgnd_1
XTAP_TAPCELL_ROW_26_191 VGND VPWR sky130_fd_sc_hd__tapvpwrvgnd_1
XFILLER_31_155 VGND VGND VPWR VPWR sky130_fd_sc_hd__decap_3
.ends
